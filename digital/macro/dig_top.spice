* NGSPICE file created from dig_top.ext - technology: sky130A

* Black-box entry subcircuit for sky130_fd_sc_hd__dfxtp_2 abstract view
.subckt sky130_fd_sc_hd__dfxtp_2 CLK D VGND VNB VPB VPWR Q
.ends

* Black-box entry subcircuit for sky130_fd_sc_hd__decap_3 abstract view
.subckt sky130_fd_sc_hd__decap_3 VGND VNB VPB VPWR
.ends

* Black-box entry subcircuit for sky130_fd_sc_hd__tapvpwrvgnd_1 abstract view
.subckt sky130_fd_sc_hd__tapvpwrvgnd_1 VGND VPWR
.ends

* Black-box entry subcircuit for sky130_fd_sc_hd__fill_2 abstract view
.subckt sky130_fd_sc_hd__fill_2 VGND VNB VPB VPWR
.ends

* Black-box entry subcircuit for sky130_fd_sc_hd__fill_1 abstract view
.subckt sky130_fd_sc_hd__fill_1 VGND VNB VPB VPWR
.ends

* Black-box entry subcircuit for sky130_fd_sc_hd__a22o_2 abstract view
.subckt sky130_fd_sc_hd__a22o_2 A1 A2 B1 B2 VGND VNB VPB VPWR X
.ends

* Black-box entry subcircuit for sky130_fd_sc_hd__nand2b_2 abstract view
.subckt sky130_fd_sc_hd__nand2b_2 A_N B VGND VNB VPB VPWR Y
.ends

* Black-box entry subcircuit for sky130_fd_sc_hd__mux2_1 abstract view
.subckt sky130_fd_sc_hd__mux2_1 A0 A1 S VGND VNB VPB VPWR X
.ends

* Black-box entry subcircuit for sky130_fd_sc_hd__a21o_2 abstract view
.subckt sky130_fd_sc_hd__a21o_2 A1 A2 B1 VGND VNB VPB VPWR X
.ends

* Black-box entry subcircuit for sky130_fd_sc_hd__or2_2 abstract view
.subckt sky130_fd_sc_hd__or2_2 A B VGND VNB VPB VPWR X
.ends

* Black-box entry subcircuit for sky130_fd_sc_hd__o211a_2 abstract view
.subckt sky130_fd_sc_hd__o211a_2 A1 A2 B1 C1 VGND VNB VPB VPWR X
.ends

* Black-box entry subcircuit for sky130_fd_sc_hd__dlygate4sd3_1 abstract view
.subckt sky130_fd_sc_hd__dlygate4sd3_1 A VGND VNB VPB VPWR X
.ends

* Black-box entry subcircuit for sky130_fd_sc_hd__nand2_2 abstract view
.subckt sky130_fd_sc_hd__nand2_2 A B VGND VNB VPB VPWR Y
.ends

* Black-box entry subcircuit for sky130_fd_sc_hd__xnor2_2 abstract view
.subckt sky130_fd_sc_hd__xnor2_2 A B VGND VNB VPB VPWR Y
.ends

* Black-box entry subcircuit for sky130_fd_sc_hd__or3b_2 abstract view
.subckt sky130_fd_sc_hd__or3b_2 A B C_N VGND VNB VPB VPWR X
.ends

* Black-box entry subcircuit for sky130_fd_sc_hd__nand3_2 abstract view
.subckt sky130_fd_sc_hd__nand3_2 A B C VGND VNB VPB VPWR Y
.ends

* Black-box entry subcircuit for sky130_fd_sc_hd__a221o_2 abstract view
.subckt sky130_fd_sc_hd__a221o_2 A1 A2 B1 B2 C1 VGND VNB VPB VPWR X
.ends

* Black-box entry subcircuit for sky130_fd_sc_hd__a31o_2 abstract view
.subckt sky130_fd_sc_hd__a31o_2 A1 A2 A3 B1 VGND VNB VPB VPWR X
.ends

* Black-box entry subcircuit for sky130_fd_sc_hd__nor2_2 abstract view
.subckt sky130_fd_sc_hd__nor2_2 A B VGND VNB VPB VPWR Y
.ends

* Black-box entry subcircuit for sky130_fd_sc_hd__and4b_2 abstract view
.subckt sky130_fd_sc_hd__and4b_2 A_N B C D VGND VNB VPB VPWR X
.ends

* Black-box entry subcircuit for sky130_fd_sc_hd__and3_2 abstract view
.subckt sky130_fd_sc_hd__and3_2 A B C VGND VNB VPB VPWR X
.ends

* Black-box entry subcircuit for sky130_fd_sc_hd__or4b_2 abstract view
.subckt sky130_fd_sc_hd__or4b_2 A B C D_N VGND VNB VPB VPWR X
.ends

* Black-box entry subcircuit for sky130_fd_sc_hd__mux4_2 abstract view
.subckt sky130_fd_sc_hd__mux4_2 A0 A1 A2 A3 S0 S1 VGND VNB VPB VPWR X
.ends

* Black-box entry subcircuit for sky130_fd_sc_hd__or3_2 abstract view
.subckt sky130_fd_sc_hd__or3_2 A B C VGND VNB VPB VPWR X
.ends

* Black-box entry subcircuit for sky130_fd_sc_hd__or4_2 abstract view
.subckt sky130_fd_sc_hd__or4_2 A B C D VGND VNB VPB VPWR X
.ends

* Black-box entry subcircuit for sky130_fd_sc_hd__clkdlybuf4s25_1 abstract view
.subckt sky130_fd_sc_hd__clkdlybuf4s25_1 A VGND VNB VPB VPWR X
.ends

* Black-box entry subcircuit for sky130_fd_sc_hd__and2b_2 abstract view
.subckt sky130_fd_sc_hd__and2b_2 A_N B VGND VNB VPB VPWR X
.ends

* Black-box entry subcircuit for sky130_fd_sc_hd__and2_2 abstract view
.subckt sky130_fd_sc_hd__and2_2 A B VGND VNB VPB VPWR X
.ends

* Black-box entry subcircuit for sky130_fd_sc_hd__inv_2 abstract view
.subckt sky130_fd_sc_hd__inv_2 A VGND VNB VPB VPWR Y
.ends

* Black-box entry subcircuit for sky130_fd_sc_hd__a21oi_2 abstract view
.subckt sky130_fd_sc_hd__a21oi_2 A1 A2 B1 VGND VNB VPB VPWR Y
.ends

* Black-box entry subcircuit for sky130_fd_sc_hd__o31a_2 abstract view
.subckt sky130_fd_sc_hd__o31a_2 A1 A2 A3 B1 VGND VNB VPB VPWR X
.ends

* Black-box entry subcircuit for sky130_fd_sc_hd__o21ai_2 abstract view
.subckt sky130_fd_sc_hd__o21ai_2 A1 A2 B1 VGND VNB VPB VPWR Y
.ends

* Black-box entry subcircuit for sky130_fd_sc_hd__o21a_2 abstract view
.subckt sky130_fd_sc_hd__o21a_2 A1 A2 B1 VGND VNB VPB VPWR X
.ends

* Black-box entry subcircuit for sky130_fd_sc_hd__xor2_2 abstract view
.subckt sky130_fd_sc_hd__xor2_2 A B VGND VNB VPB VPWR X
.ends

* Black-box entry subcircuit for sky130_fd_sc_hd__buf_4 abstract view
.subckt sky130_fd_sc_hd__buf_4 A VGND VNB VPB VPWR X
.ends

* Black-box entry subcircuit for sky130_fd_sc_hd__a32o_2 abstract view
.subckt sky130_fd_sc_hd__a32o_2 A1 A2 A3 B1 B2 VGND VNB VPB VPWR X
.ends

* Black-box entry subcircuit for sky130_fd_sc_hd__nor3_2 abstract view
.subckt sky130_fd_sc_hd__nor3_2 A B C VGND VNB VPB VPWR Y
.ends

* Black-box entry subcircuit for sky130_fd_sc_hd__clkbuf_8 abstract view
.subckt sky130_fd_sc_hd__clkbuf_8 A VGND VNB VPB VPWR X
.ends

* Black-box entry subcircuit for sky130_fd_sc_hd__nand4_2 abstract view
.subckt sky130_fd_sc_hd__nand4_2 A B C D VGND VNB VPB VPWR Y
.ends

* Black-box entry subcircuit for sky130_fd_sc_hd__clkbuf_4 abstract view
.subckt sky130_fd_sc_hd__clkbuf_4 A VGND VNB VPB VPWR X
.ends

* Black-box entry subcircuit for sky130_fd_sc_hd__nand3b_2 abstract view
.subckt sky130_fd_sc_hd__nand3b_2 A_N B C VGND VNB VPB VPWR Y
.ends

* Black-box entry subcircuit for sky130_fd_sc_hd__a211oi_2 abstract view
.subckt sky130_fd_sc_hd__a211oi_2 A1 A2 B1 C1 VGND VNB VPB VPWR Y
.ends

* Black-box entry subcircuit for sky130_fd_sc_hd__inv_6 abstract view
.subckt sky130_fd_sc_hd__inv_6 A VGND VNB VPB VPWR Y
.ends

* Black-box entry subcircuit for sky130_fd_sc_hd__a2bb2o_2 abstract view
.subckt sky130_fd_sc_hd__a2bb2o_2 A1_N A2_N B1 B2 VGND VNB VPB VPWR X
.ends

* Black-box entry subcircuit for sky130_fd_sc_hd__a211o_2 abstract view
.subckt sky130_fd_sc_hd__a211o_2 A1 A2 B1 C1 VGND VNB VPB VPWR X
.ends

* Black-box entry subcircuit for sky130_fd_sc_hd__and3b_2 abstract view
.subckt sky130_fd_sc_hd__and3b_2 A_N B C VGND VNB VPB VPWR X
.ends

* Black-box entry subcircuit for sky130_fd_sc_hd__clkbuf_16 abstract view
.subckt sky130_fd_sc_hd__clkbuf_16 A VGND VNB VPB VPWR X
.ends

* Black-box entry subcircuit for sky130_fd_sc_hd__dfrtp_2 abstract view
.subckt sky130_fd_sc_hd__dfrtp_2 CLK D RESET_B VGND VNB VPB VPWR Q
.ends

* Black-box entry subcircuit for sky130_fd_sc_hd__o311a_2 abstract view
.subckt sky130_fd_sc_hd__o311a_2 A1 A2 A3 B1 C1 VGND VNB VPB VPWR X
.ends

* Black-box entry subcircuit for sky130_fd_sc_hd__clkinv_2 abstract view
.subckt sky130_fd_sc_hd__clkinv_2 A VGND VNB VPB VPWR Y
.ends

* Black-box entry subcircuit for sky130_fd_sc_hd__nor4b_2 abstract view
.subckt sky130_fd_sc_hd__nor4b_2 A B C D_N VGND VNB VPB VPWR Y
.ends

* Black-box entry subcircuit for sky130_fd_sc_hd__clkinv_4 abstract view
.subckt sky130_fd_sc_hd__clkinv_4 A VGND VNB VPB VPWR Y
.ends

* Black-box entry subcircuit for sky130_fd_sc_hd__buf_2 abstract view
.subckt sky130_fd_sc_hd__buf_2 A VGND VNB VPB VPWR X
.ends

* Black-box entry subcircuit for sky130_fd_sc_hd__a31oi_2 abstract view
.subckt sky130_fd_sc_hd__a31oi_2 A1 A2 A3 B1 VGND VNB VPB VPWR Y
.ends

* Black-box entry subcircuit for sky130_fd_sc_hd__a21bo_2 abstract view
.subckt sky130_fd_sc_hd__a21bo_2 A1 A2 B1_N VGND VNB VPB VPWR X
.ends

* Black-box entry subcircuit for sky130_fd_sc_hd__o22a_2 abstract view
.subckt sky130_fd_sc_hd__o22a_2 A1 A2 B1 B2 VGND VNB VPB VPWR X
.ends

* Black-box entry subcircuit for sky130_fd_sc_hd__clkbuf_2 abstract view
.subckt sky130_fd_sc_hd__clkbuf_2 A VGND VNB VPB VPWR X
.ends

* Black-box entry subcircuit for sky130_fd_sc_hd__o31ai_2 abstract view
.subckt sky130_fd_sc_hd__o31ai_2 A1 A2 A3 B1 VGND VNB VPB VPWR Y
.ends

* Black-box entry subcircuit for sky130_fd_sc_hd__and4_2 abstract view
.subckt sky130_fd_sc_hd__and4_2 A B C D VGND VNB VPB VPWR X
.ends

* Black-box entry subcircuit for sky130_fd_sc_hd__o21ba_2 abstract view
.subckt sky130_fd_sc_hd__o21ba_2 A1 A2 B1_N VGND VNB VPB VPWR X
.ends

* Black-box entry subcircuit for sky130_fd_sc_hd__nor4_2 abstract view
.subckt sky130_fd_sc_hd__nor4_2 A B C D VGND VNB VPB VPWR Y
.ends

* Black-box entry subcircuit for sky130_fd_sc_hd__conb_1 abstract view
.subckt sky130_fd_sc_hd__conb_1 VGND VNB VPB VPWR HI LO
.ends

* Black-box entry subcircuit for sky130_fd_sc_hd__buf_1 abstract view
.subckt sky130_fd_sc_hd__buf_1 A VGND VNB VPB VPWR X
.ends

* Black-box entry subcircuit for sky130_fd_sc_hd__o22ai_2 abstract view
.subckt sky130_fd_sc_hd__o22ai_2 A1 A2 B1 B2 VGND VNB VPB VPWR Y
.ends

* Black-box entry subcircuit for sky130_fd_sc_hd__o21bai_2 abstract view
.subckt sky130_fd_sc_hd__o21bai_2 A1 A2 B1_N VGND VNB VPB VPWR Y
.ends

* Black-box entry subcircuit for sky130_fd_sc_hd__o211ai_2 abstract view
.subckt sky130_fd_sc_hd__o211ai_2 A1 A2 B1 C1 VGND VNB VPB VPWR Y
.ends

* Black-box entry subcircuit for sky130_fd_sc_hd__o32a_2 abstract view
.subckt sky130_fd_sc_hd__o32a_2 A1 A2 A3 B1 B2 VGND VNB VPB VPWR X
.ends

* Black-box entry subcircuit for sky130_fd_sc_hd__o221a_2 abstract view
.subckt sky130_fd_sc_hd__o221a_2 A1 A2 B1 B2 C1 VGND VNB VPB VPWR X
.ends

* Black-box entry subcircuit for sky130_fd_sc_hd__o2111a_2 abstract view
.subckt sky130_fd_sc_hd__o2111a_2 A1 A2 B1 C1 D1 VGND VNB VPB VPWR X
.ends

* Black-box entry subcircuit for sky130_fd_sc_hd__nor3b_2 abstract view
.subckt sky130_fd_sc_hd__nor3b_2 A B C_N VGND VNB VPB VPWR Y
.ends

* Black-box entry subcircuit for sky130_fd_sc_hd__a2111o_2 abstract view
.subckt sky130_fd_sc_hd__a2111o_2 A1 A2 B1 C1 D1 VGND VNB VPB VPWR X
.ends

* Black-box entry subcircuit for sky130_fd_sc_hd__a311oi_2 abstract view
.subckt sky130_fd_sc_hd__a311oi_2 A1 A2 A3 B1 C1 VGND VNB VPB VPWR Y
.ends

* Black-box entry subcircuit for sky130_fd_sc_hd__a221oi_2 abstract view
.subckt sky130_fd_sc_hd__a221oi_2 A1 A2 B1 B2 C1 VGND VNB VPB VPWR Y
.ends

* Black-box entry subcircuit for sky130_fd_sc_hd__or4bb_2 abstract view
.subckt sky130_fd_sc_hd__or4bb_2 A B C_N D_N VGND VNB VPB VPWR X
.ends

.subckt dig_top VGND VPWR a_sel0[0] a_sel0[1] a_sel0[2] a_sel0[3] a_sel1[0] a_sel1[1]
+ a_sel1[2] a_sel1[3] a_selb0[0] a_selb0[1] a_selb0[2] a_selb0[3] a_selb1[0] a_selb1[1]
+ a_selb1[2] a_selb1[3] adc_en clk ena osc_en osc_in por_n_in rst_n ui_in[0] ui_in[1]
+ ui_in[2] ui_in[3] ui_in[4] ui_in[5] ui_in[6] ui_in[7] uio_in[0] uio_in[1] uio_in[2]
+ uio_in[3] uio_in[4] uio_in[5] uio_in[6] uio_in[7] uio_oe[0] uio_oe[1] uio_oe[2]
+ uio_oe[3] uio_oe[4] uio_oe[5] uio_oe[6] uio_oe[7] uio_out[0] uio_out[1] uio_out[2]
+ uio_out[3] uio_out[4] uio_out[5] uio_out[6] uio_out[7] uo_out[0] uo_out[1] uo_out[2]
+ uo_out[3] uo_out[4] uo_out[5] uo_out[6] uo_out[7]
X_2037_ clkload4/A _2037_/D VGND VGND VPWR VPWR _2137_/A sky130_fd_sc_hd__dfxtp_2
X_2106_ clkload8/A _2106_/D VGND VGND VPWR VPWR _2106_/Q sky130_fd_sc_hd__dfxtp_2
XFILLER_39_266 VGND VGND VPWR VPWR sky130_fd_sc_hd__decap_3
XTAP_TAPCELL_ROW_52_404 VGND VPWR sky130_fd_sc_hd__tapvpwrvgnd_1
XFILLER_10_306 VGND VGND VPWR VPWR sky130_fd_sc_hd__fill_2
XFILLER_26_96 VGND VGND VPWR VPWR sky130_fd_sc_hd__fill_1
XFILLER_26_85 VGND VGND VPWR VPWR sky130_fd_sc_hd__fill_2
XFILLER_13_122 VGND VGND VPWR VPWR sky130_fd_sc_hd__fill_1
XFILLER_13_199 VGND VGND VPWR VPWR sky130_fd_sc_hd__decap_3
XFILLER_3_12 VGND VGND VPWR VPWR sky130_fd_sc_hd__fill_2
XFILLER_36_269 VGND VGND VPWR VPWR sky130_fd_sc_hd__decap_3
XFILLER_36_258 VGND VGND VPWR VPWR sky130_fd_sc_hd__decap_3
X_1270_ _1264_/X _1266_/X _1269_/X _1279_/A1 VGND VGND VPWR VPWR _1306_/A sky130_fd_sc_hd__a22o_2
X_0985_ _2080_/Q _2046_/Q VGND VGND VPWR VPWR _0985_/Y sky130_fd_sc_hd__nand2b_2
X_1606_ hold185/X _1506_/A _1608_/S VGND VGND VPWR VPWR _1969_/D sky130_fd_sc_hd__mux2_1
X_1537_ hold157/X _1529_/X _1536_/Y VGND VGND VPWR VPWR _1931_/D sky130_fd_sc_hd__a21o_2
X_1468_ _1794_/B _1599_/A VGND VGND VPWR VPWR _1619_/B sky130_fd_sc_hd__or2_2
X_1399_ _1895_/Q _1402_/B _1398_/Y _1837_/C VGND VGND VPWR VPWR _1895_/D sky130_fd_sc_hd__o211a_2
XPHY_EDGE_ROW_19_Left_72 VGND VGND VPWR VPWR sky130_fd_sc_hd__decap_3
Xhold170 _2107_/Q VGND VGND VPWR VPWR hold170/X sky130_fd_sc_hd__dlygate4sd3_1
Xhold192 _1932_/Q VGND VGND VPWR VPWR hold192/X sky130_fd_sc_hd__dlygate4sd3_1
Xhold181 _1988_/Q VGND VGND VPWR VPWR hold181/X sky130_fd_sc_hd__dlygate4sd3_1
XFILLER_2_302 VGND VGND VPWR VPWR sky130_fd_sc_hd__decap_3
XFILLER_12_76 VGND VGND VPWR VPWR sky130_fd_sc_hd__fill_1
XTAP_TAPCELL_ROW_5_140 VGND VPWR sky130_fd_sc_hd__tapvpwrvgnd_1
XFILLER_41_261 VGND VGND VPWR VPWR sky130_fd_sc_hd__fill_2
XFILLER_37_95 VGND VGND VPWR VPWR sky130_fd_sc_hd__decap_3
XFILLER_33_206 VGND VGND VPWR VPWR sky130_fd_sc_hd__fill_1
XFILLER_26_280 VGND VGND VPWR VPWR sky130_fd_sc_hd__decap_3
XFILLER_5_162 VGND VGND VPWR VPWR sky130_fd_sc_hd__decap_3
XTAP_TAPCELL_ROW_11_175 VGND VPWR sky130_fd_sc_hd__tapvpwrvgnd_1
X_1322_ _1325_/A _1400_/A VGND VGND VPWR VPWR _1322_/Y sky130_fd_sc_hd__nand2_2
X_1253_ _1697_/A _1312_/A VGND VGND VPWR VPWR _1254_/D sky130_fd_sc_hd__xnor2_2
XFILLER_24_228 VGND VGND VPWR VPWR sky130_fd_sc_hd__fill_1
X_1184_ _1266_/B1 _1080_/X _1279_/A1 _1183_/X VGND VGND VPWR VPWR _1296_/A sky130_fd_sc_hd__a22o_2
XTAP_TAPCELL_ROW_19_220 VGND VPWR sky130_fd_sc_hd__tapvpwrvgnd_1
XFILLER_32_283 VGND VGND VPWR VPWR sky130_fd_sc_hd__decap_3
XFILLER_32_250 VGND VGND VPWR VPWR sky130_fd_sc_hd__fill_2
X_0968_ _2040_/Q _2039_/Q _2038_/Q VGND VGND VPWR VPWR a_selb0[0] sky130_fd_sc_hd__or3b_2
XFILLER_23_250 VGND VGND VPWR VPWR sky130_fd_sc_hd__decap_3
XPHY_EDGE_ROW_4_Left_57 VGND VGND VPWR VPWR sky130_fd_sc_hd__decap_3
XFILLER_48_83 VGND VGND VPWR VPWR sky130_fd_sc_hd__fill_1
XFILLER_46_320 VGND VGND VPWR VPWR sky130_fd_sc_hd__decap_3
XTAP_TAPCELL_ROW_16_201 VGND VPWR sky130_fd_sc_hd__tapvpwrvgnd_1
X_1940_ _2036_/CLK _1940_/D VGND VGND VPWR VPWR _1940_/Q sky130_fd_sc_hd__dfxtp_2
X_1871_ clkload7/A _1871_/D VGND VGND VPWR VPWR _1871_/Q sky130_fd_sc_hd__dfxtp_2
XTAP_TAPCELL_ROW_39_326 VGND VPWR sky130_fd_sc_hd__tapvpwrvgnd_1
X_1305_ _1854_/Q _1310_/A _1304_/Y _1389_/C1 VGND VGND VPWR VPWR _1854_/D sky130_fd_sc_hd__o211a_2
X_1236_ _1236_/A _1236_/B _1236_/C VGND VGND VPWR VPWR _1237_/B sky130_fd_sc_hd__nand3_2
XTAP_TAPCELL_ROW_47_370 VGND VPWR sky130_fd_sc_hd__tapvpwrvgnd_1
XPHY_EDGE_ROW_46_Left_99 VGND VGND VPWR VPWR sky130_fd_sc_hd__decap_3
X_1167_ _1167_/A _1167_/B VGND VGND VPWR VPWR _1206_/A sky130_fd_sc_hd__nand2_2
X_1098_ _1178_/A _1172_/B VGND VGND VPWR VPWR _1098_/X sky130_fd_sc_hd__or2_2
XTAP_TAPCELL_ROW_30_281 VGND VPWR sky130_fd_sc_hd__tapvpwrvgnd_1
XTAP_TAPCELL_ROW_22_237 VGND VPWR sky130_fd_sc_hd__tapvpwrvgnd_1
XFILLER_20_253 VGND VGND VPWR VPWR sky130_fd_sc_hd__fill_2
XFILLER_47_106 VGND VGND VPWR VPWR sky130_fd_sc_hd__decap_3
XFILLER_34_85 VGND VGND VPWR VPWR sky130_fd_sc_hd__decap_3
XFILLER_34_41 VGND VGND VPWR VPWR sky130_fd_sc_hd__decap_3
XFILLER_7_268 VGND VGND VPWR VPWR sky130_fd_sc_hd__decap_3
X_2070_ clkload1/A _2070_/D VGND VGND VPWR VPWR _2070_/Q sky130_fd_sc_hd__dfxtp_2
XFILLER_15_6 VGND VGND VPWR VPWR sky130_fd_sc_hd__fill_1
XFILLER_46_161 VGND VGND VPWR VPWR sky130_fd_sc_hd__fill_1
X_1021_ _1856_/Q _1371_/A1 _1337_/B2 _1892_/Q _1020_/X VGND VGND VPWR VPWR _1102_/A
+ sky130_fd_sc_hd__a221o_2
X_1923_ clkload3/A _1923_/D VGND VGND VPWR VPWR _1923_/Q sky130_fd_sc_hd__dfxtp_2
X_1854_ _1899_/CLK _1854_/D VGND VGND VPWR VPWR _1854_/Q sky130_fd_sc_hd__dfxtp_2
X_1785_ _1809_/A1 _2057_/Q _1789_/B1 _1784_/X VGND VGND VPWR VPWR _2058_/D sky130_fd_sc_hd__o211a_2
XFILLER_25_323 VGND VGND VPWR VPWR sky130_fd_sc_hd__fill_1
X_1219_ _1180_/A _1180_/B _1180_/C _1218_/Y VGND VGND VPWR VPWR _1219_/X sky130_fd_sc_hd__a31o_2
XFILLER_52_197 VGND VGND VPWR VPWR sky130_fd_sc_hd__decap_3
XTAP_TAPCELL_ROW_50_387 VGND VPWR sky130_fd_sc_hd__tapvpwrvgnd_1
XFILLER_43_186 VGND VGND VPWR VPWR sky130_fd_sc_hd__decap_3
XPHY_EDGE_ROW_7_Left_60 VGND VGND VPWR VPWR sky130_fd_sc_hd__decap_3
X_1570_ _1683_/A _1570_/B VGND VGND VPWR VPWR _1570_/Y sky130_fd_sc_hd__nor2_2
XFILLER_6_78 VGND VGND VPWR VPWR sky130_fd_sc_hd__decap_3
X_2053_ _2058_/CLK _2053_/D VGND VGND VPWR VPWR _2053_/Q sky130_fd_sc_hd__dfxtp_2
XFILLER_19_172 VGND VGND VPWR VPWR sky130_fd_sc_hd__decap_3
X_1004_ _1834_/A _1449_/A VGND VGND VPWR VPWR _1462_/A sky130_fd_sc_hd__or2_2
X_1837_ _1903_/Q _1902_/Q _1837_/C _1846_/D VGND VGND VPWR VPWR _1839_/S sky130_fd_sc_hd__and4b_2
X_1906_ clkload9/A _1906_/D VGND VGND VPWR VPWR _1906_/Q sky130_fd_sc_hd__dfxtp_2
X_1768_ _1806_/A _2050_/Q VGND VGND VPWR VPWR _1768_/X sky130_fd_sc_hd__or2_2
X_1699_ _2018_/Q _1707_/B VGND VGND VPWR VPWR _1699_/X sky130_fd_sc_hd__or2_2
XFILLER_13_304 VGND VGND VPWR VPWR sky130_fd_sc_hd__decap_3
XFILLER_17_109 VGND VGND VPWR VPWR sky130_fd_sc_hd__decap_3
XFILLER_40_189 VGND VGND VPWR VPWR sky130_fd_sc_hd__fill_2
XFILLER_25_186 VGND VGND VPWR VPWR sky130_fd_sc_hd__decap_3
XFILLER_9_308 VGND VGND VPWR VPWR sky130_fd_sc_hd__fill_2
XFILLER_15_65 VGND VGND VPWR VPWR sky130_fd_sc_hd__decap_3
XPHY_EDGE_ROW_33_Left_86 VGND VGND VPWR VPWR sky130_fd_sc_hd__decap_3
XFILLER_48_267 VGND VGND VPWR VPWR sky130_fd_sc_hd__decap_3
XFILLER_0_296 VGND VGND VPWR VPWR sky130_fd_sc_hd__fill_2
XFILLER_16_197 VGND VGND VPWR VPWR sky130_fd_sc_hd__decap_3
X_1622_ _1626_/A _1622_/B _1626_/C VGND VGND VPWR VPWR _1622_/X sky130_fd_sc_hd__and3_2
X_1553_ _1683_/A _1553_/B VGND VGND VPWR VPWR _1553_/Y sky130_fd_sc_hd__nor2_2
X_1484_ _2071_/Q _1484_/B _1484_/C _2077_/Q VGND VGND VPWR VPWR _1686_/B sky130_fd_sc_hd__or4b_2
XTAP_TAPCELL_ROW_52_405 VGND VPWR sky130_fd_sc_hd__tapvpwrvgnd_1
X_2036_ _2036_/CLK _2036_/D VGND VGND VPWR VPWR _2036_/Q sky130_fd_sc_hd__dfxtp_2
X_2105_ _2114_/CLK _2105_/D VGND VGND VPWR VPWR _2105_/Q sky130_fd_sc_hd__dfxtp_2
XFILLER_39_289 VGND VGND VPWR VPWR sky130_fd_sc_hd__decap_3
XFILLER_39_278 VGND VGND VPWR VPWR sky130_fd_sc_hd__fill_2
XFILLER_9_116 VGND VGND VPWR VPWR sky130_fd_sc_hd__fill_2
XFILLER_42_85 VGND VGND VPWR VPWR sky130_fd_sc_hd__decap_3
XFILLER_3_57 VGND VGND VPWR VPWR sky130_fd_sc_hd__fill_2
XTAP_TAPCELL_ROW_8_160 VGND VPWR sky130_fd_sc_hd__tapvpwrvgnd_1
X_0984_ _2086_/Q _2088_/Q _2090_/Q _2092_/Q _2046_/Q _2047_/Q VGND VGND VPWR VPWR
+ _0984_/X sky130_fd_sc_hd__mux4_2
X_1536_ _1683_/A _1536_/B VGND VGND VPWR VPWR _1536_/Y sky130_fd_sc_hd__nor2_2
X_1605_ hold159/X _1521_/A _1608_/S VGND VGND VPWR VPWR _1968_/D sky130_fd_sc_hd__mux2_1
X_1467_ _1794_/B _1599_/A VGND VGND VPWR VPWR _1626_/A sky130_fd_sc_hd__nor2_2
X_1398_ _1398_/A _1402_/B VGND VGND VPWR VPWR _1398_/Y sky130_fd_sc_hd__nand2_2
XFILLER_50_240 VGND VGND VPWR VPWR sky130_fd_sc_hd__decap_3
XFILLER_35_292 VGND VGND VPWR VPWR sky130_fd_sc_hd__decap_3
X_2019_ clkload1/A _2019_/D VGND VGND VPWR VPWR _2019_/Q sky130_fd_sc_hd__dfxtp_2
XFILLER_12_11 VGND VGND VPWR VPWR sky130_fd_sc_hd__decap_3
Xhold193 _1903_/Q VGND VGND VPWR VPWR hold193/X sky130_fd_sc_hd__dlygate4sd3_1
Xhold160 _1983_/Q VGND VGND VPWR VPWR hold160/X sky130_fd_sc_hd__dlygate4sd3_1
Xhold182 _1982_/Q VGND VGND VPWR VPWR hold182/X sky130_fd_sc_hd__dlygate4sd3_1
Xhold171 _1965_/Q VGND VGND VPWR VPWR hold171/X sky130_fd_sc_hd__dlygate4sd3_1
XFILLER_37_63 VGND VGND VPWR VPWR sky130_fd_sc_hd__decap_3
XTAP_TAPCELL_ROW_28_265 VGND VPWR sky130_fd_sc_hd__tapvpwrvgnd_1
XTAP_TAPCELL_ROW_5_141 VGND VPWR sky130_fd_sc_hd__tapvpwrvgnd_1
XFILLER_18_237 VGND VGND VPWR VPWR sky130_fd_sc_hd__decap_3
XFILLER_26_292 VGND VGND VPWR VPWR sky130_fd_sc_hd__fill_2
XTAP_TAPCELL_ROW_11_176 VGND VPWR sky130_fd_sc_hd__tapvpwrvgnd_1
X_1321_ _1321_/A _1327_/B _1327_/C VGND VGND VPWR VPWR _1400_/A sky130_fd_sc_hd__or3_2
X_1252_ _1697_/A _1312_/A VGND VGND VPWR VPWR _1252_/X sky130_fd_sc_hd__or2_2
XPHY_EDGE_ROW_20_Left_73 VGND VGND VPWR VPWR sky130_fd_sc_hd__decap_3
X_1183_ _1180_/A _1180_/B _1180_/C _1182_/X VGND VGND VPWR VPWR _1183_/X sky130_fd_sc_hd__a31o_2
X_0967_ _1904_/Q _1905_/Q _1906_/Q _0967_/D VGND VGND VPWR VPWR _2134_/A sky130_fd_sc_hd__or4_2
X_1519_ _1794_/B _1790_/B _1792_/B VGND VGND VPWR VPWR _1588_/A sky130_fd_sc_hd__or3b_2
XPHY_EDGE_ROW_12_Right_12 VGND VGND VPWR VPWR sky130_fd_sc_hd__decap_3
XTAP_TAPCELL_ROW_2_122 VGND VPWR sky130_fd_sc_hd__tapvpwrvgnd_1
XPHY_EDGE_ROW_21_Right_21 VGND VGND VPWR VPWR sky130_fd_sc_hd__decap_3
XFILLER_23_262 VGND VGND VPWR VPWR sky130_fd_sc_hd__decap_3
XFILLER_15_218 VGND VGND VPWR VPWR sky130_fd_sc_hd__fill_1
XPHY_EDGE_ROW_30_Right_30 VGND VGND VPWR VPWR sky130_fd_sc_hd__decap_3
XFILLER_48_62 VGND VGND VPWR VPWR sky130_fd_sc_hd__fill_1
XFILLER_2_155 VGND VGND VPWR VPWR sky130_fd_sc_hd__decap_3
XFILLER_0_25 VGND VGND VPWR VPWR sky130_fd_sc_hd__decap_3
XTAP_TAPCELL_ROW_16_202 VGND VPWR sky130_fd_sc_hd__tapvpwrvgnd_1
X_1870_ _1897_/CLK _1870_/D VGND VGND VPWR VPWR _1870_/Q sky130_fd_sc_hd__dfxtp_2
XFILLER_9_67 VGND VGND VPWR VPWR sky130_fd_sc_hd__decap_3
XFILLER_14_251 VGND VGND VPWR VPWR sky130_fd_sc_hd__fill_1
XFILLER_14_262 VGND VGND VPWR VPWR sky130_fd_sc_hd__decap_3
XFILLER_43_3 VGND VGND VPWR VPWR sky130_fd_sc_hd__decap_3
XFILLER_49_192 VGND VGND VPWR VPWR sky130_fd_sc_hd__fill_1
XTAP_TAPCELL_ROW_39_327 VGND VPWR sky130_fd_sc_hd__tapvpwrvgnd_1
X_1304_ _1310_/A _1388_/A VGND VGND VPWR VPWR _1304_/Y sky130_fd_sc_hd__nand2_2
X_1235_ _1236_/C _1235_/B VGND VGND VPWR VPWR _1235_/Y sky130_fd_sc_hd__xnor2_2
X_1166_ _1166_/A _1166_/B VGND VGND VPWR VPWR _1167_/B sky130_fd_sc_hd__nor2_2
XTAP_TAPCELL_ROW_47_371 VGND VPWR sky130_fd_sc_hd__tapvpwrvgnd_1
X_1097_ _1087_/Y _1089_/X _1096_/X _1147_/A VGND VGND VPWR VPWR _1178_/B sky130_fd_sc_hd__a22o_2
X_1999_ clkload4/A _1999_/D VGND VGND VPWR VPWR _1999_/Q sky130_fd_sc_hd__dfxtp_2
XFILLER_28_321 VGND VGND VPWR VPWR sky130_fd_sc_hd__decap_3
XFILLER_7_203 VGND VGND VPWR VPWR sky130_fd_sc_hd__decap_3
XFILLER_7_236 VGND VGND VPWR VPWR sky130_fd_sc_hd__decap_3
XFILLER_11_210 VGND VGND VPWR VPWR sky130_fd_sc_hd__decap_3
XFILLER_50_85 VGND VGND VPWR VPWR sky130_fd_sc_hd__fill_1
X_1020_ _1868_/Q _0999_/X _1337_/A1 _1880_/Q VGND VGND VPWR VPWR _1020_/X sky130_fd_sc_hd__a22o_2
X_1922_ _2065_/CLK _1922_/D VGND VGND VPWR VPWR _1922_/Q sky130_fd_sc_hd__dfxtp_2
X_1853_ clkload6/A _1853_/D VGND VGND VPWR VPWR _1853_/Q sky130_fd_sc_hd__dfxtp_2
X_1784_ _1808_/A _2058_/Q VGND VGND VPWR VPWR _1784_/X sky130_fd_sc_hd__or2_2
Xfanout8 _1294_/X VGND VGND VPWR VPWR _1327_/C sky130_fd_sc_hd__clkdlybuf4s25_1
XFILLER_29_118 VGND VGND VPWR VPWR sky130_fd_sc_hd__decap_3
XFILLER_37_140 VGND VGND VPWR VPWR sky130_fd_sc_hd__fill_2
X_1149_ _1149_/A _1149_/B _1149_/C VGND VGND VPWR VPWR _1150_/B sky130_fd_sc_hd__or3_2
X_1218_ _1218_/A _1218_/B VGND VGND VPWR VPWR _1218_/Y sky130_fd_sc_hd__xnor2_2
XTAP_TAPCELL_ROW_50_388 VGND VPWR sky130_fd_sc_hd__tapvpwrvgnd_1
XFILLER_4_217 VGND VGND VPWR VPWR sky130_fd_sc_hd__decap_3
XFILLER_20_77 VGND VGND VPWR VPWR sky130_fd_sc_hd__fill_2
XFILLER_29_86 VGND VGND VPWR VPWR sky130_fd_sc_hd__decap_3
XPHY_EDGE_ROW_51_Left_104 VGND VGND VPWR VPWR sky130_fd_sc_hd__decap_3
XFILLER_43_165 VGND VGND VPWR VPWR sky130_fd_sc_hd__decap_3
XFILLER_43_110 VGND VGND VPWR VPWR sky130_fd_sc_hd__fill_2
XFILLER_31_316 VGND VGND VPWR VPWR sky130_fd_sc_hd__decap_3
X_1003_ _1449_/A _1003_/B VGND VGND VPWR VPWR _1003_/X sky130_fd_sc_hd__and2b_2
X_2052_ _2077_/CLK _2052_/D VGND VGND VPWR VPWR _2052_/Q sky130_fd_sc_hd__dfxtp_2
XFILLER_19_140 VGND VGND VPWR VPWR sky130_fd_sc_hd__decap_3
X_1905_ clkload8/A _1905_/D VGND VGND VPWR VPWR _1905_/Q sky130_fd_sc_hd__dfxtp_2
X_1836_ _1840_/B hold195/X _1836_/S VGND VGND VPWR VPWR _2106_/D sky130_fd_sc_hd__mux2_1
X_1767_ _1809_/A1 _2097_/Q _1805_/B1 _1766_/X VGND VGND VPWR VPWR _2049_/D sky130_fd_sc_hd__o211a_2
X_1698_ _2054_/Q _1697_/B _1697_/Y _1749_/C1 VGND VGND VPWR VPWR _2017_/D sky130_fd_sc_hd__o211a_2
XPHY_EDGE_ROW_6_Right_6 VGND VGND VPWR VPWR sky130_fd_sc_hd__decap_3
XFILLER_25_121 VGND VGND VPWR VPWR sky130_fd_sc_hd__decap_3
XFILLER_31_87 VGND VGND VPWR VPWR sky130_fd_sc_hd__decap_3
XFILLER_0_264 VGND VGND VPWR VPWR sky130_fd_sc_hd__decap_3
XFILLER_0_242 VGND VGND VPWR VPWR sky130_fd_sc_hd__decap_3
XFILLER_16_121 VGND VGND VPWR VPWR sky130_fd_sc_hd__decap_3
X_1552_ hold123/X _1546_/X _1551_/Y VGND VGND VPWR VPWR _1938_/D sky130_fd_sc_hd__a21o_2
X_1621_ _1980_/Q _1619_/X _1620_/X VGND VGND VPWR VPWR _1980_/D sky130_fd_sc_hd__a21o_2
X_2104_ _2115_/CLK _2104_/D VGND VGND VPWR VPWR _2104_/Q sky130_fd_sc_hd__dfxtp_2
X_1483_ _1483_/A _1483_/B _1483_/C VGND VGND VPWR VPWR _1484_/C sky130_fd_sc_hd__or3_2
XTAP_TAPCELL_ROW_52_406 VGND VPWR sky130_fd_sc_hd__tapvpwrvgnd_1
X_2035_ _2035_/CLK _2035_/D VGND VGND VPWR VPWR _2035_/Q sky130_fd_sc_hd__dfxtp_2
X_1819_ _1824_/A _1819_/B VGND VGND VPWR VPWR _2073_/D sky130_fd_sc_hd__and2_2
XFILLER_13_113 VGND VGND VPWR VPWR sky130_fd_sc_hd__decap_3
XFILLER_42_97 VGND VGND VPWR VPWR sky130_fd_sc_hd__decap_3
XFILLER_3_25 VGND VGND VPWR VPWR sky130_fd_sc_hd__fill_2
XFILLER_29_290 VGND VGND VPWR VPWR sky130_fd_sc_hd__decap_3
X_0983_ a_selb1[3] VGND VGND VPWR VPWR a_sel1[3] sky130_fd_sc_hd__inv_2
X_1535_ hold178/X _1529_/X _1534_/Y VGND VGND VPWR VPWR _1930_/D sky130_fd_sc_hd__a21o_2
X_1604_ _1660_/A _1604_/B VGND VGND VPWR VPWR _1608_/S sky130_fd_sc_hd__nor2_2
X_1397_ _1894_/Q _1402_/B _1396_/Y _1407_/C1 VGND VGND VPWR VPWR _1894_/D sky130_fd_sc_hd__o211a_2
X_1466_ _1792_/B _1790_/B VGND VGND VPWR VPWR _1599_/A sky130_fd_sc_hd__or2_2
XFILLER_42_208 VGND VGND VPWR VPWR sky130_fd_sc_hd__decap_3
XFILLER_35_271 VGND VGND VPWR VPWR sky130_fd_sc_hd__decap_3
X_2018_ clkload1/A _2018_/D VGND VGND VPWR VPWR _2018_/Q sky130_fd_sc_hd__dfxtp_2
XFILLER_10_127 VGND VGND VPWR VPWR sky130_fd_sc_hd__decap_3
XFILLER_12_45 VGND VGND VPWR VPWR sky130_fd_sc_hd__fill_2
Xhold150 _1998_/Q VGND VGND VPWR VPWR hold150/X sky130_fd_sc_hd__dlygate4sd3_1
Xhold161 _1942_/Q VGND VGND VPWR VPWR hold161/X sky130_fd_sc_hd__dlygate4sd3_1
Xhold194 _1924_/Q VGND VGND VPWR VPWR hold194/X sky130_fd_sc_hd__dlygate4sd3_1
Xhold183 _1959_/Q VGND VGND VPWR VPWR hold183/X sky130_fd_sc_hd__dlygate4sd3_1
XTAP_TAPCELL_ROW_5_142 VGND VPWR sky130_fd_sc_hd__tapvpwrvgnd_1
Xhold172 _1977_/Q VGND VGND VPWR VPWR hold172/X sky130_fd_sc_hd__dlygate4sd3_1
XTAP_TAPCELL_ROW_28_266 VGND VPWR sky130_fd_sc_hd__tapvpwrvgnd_1
XFILLER_26_271 VGND VGND VPWR VPWR sky130_fd_sc_hd__decap_3
XFILLER_5_142 VGND VGND VPWR VPWR sky130_fd_sc_hd__decap_3
X_1320_ _1859_/Q _1325_/A _1319_/Y _1395_/C1 VGND VGND VPWR VPWR _1859_/D sky130_fd_sc_hd__o211a_2
X_1182_ _1277_/A _1182_/B VGND VGND VPWR VPWR _1182_/X sky130_fd_sc_hd__or2_2
X_1251_ _1179_/X _1250_/X _1247_/X VGND VGND VPWR VPWR _1312_/A sky130_fd_sc_hd__a21oi_2
XFILLER_32_263 VGND VGND VPWR VPWR sky130_fd_sc_hd__decap_3
X_0966_ _1908_/Q _1907_/Q _1911_/Q VGND VGND VPWR VPWR _0967_/D sky130_fd_sc_hd__or3_2
XFILLER_32_296 VGND VGND VPWR VPWR sky130_fd_sc_hd__decap_3
X_1449_ _1449_/A _1908_/Q _1907_/Q VGND VGND VPWR VPWR _1449_/X sky130_fd_sc_hd__and3_2
X_1518_ _1518_/A1 _1497_/A _1515_/X _1514_/X VGND VGND VPWR VPWR _1923_/D sky130_fd_sc_hd__a31o_2
XFILLER_4_90 VGND VGND VPWR VPWR sky130_fd_sc_hd__fill_1
XTAP_TAPCELL_ROW_2_123 VGND VPWR sky130_fd_sc_hd__tapvpwrvgnd_1
XFILLER_3_3 VGND VGND VPWR VPWR sky130_fd_sc_hd__decap_3
XFILLER_48_96 VGND VGND VPWR VPWR sky130_fd_sc_hd__fill_2
XFILLER_0_15 VGND VGND VPWR VPWR sky130_fd_sc_hd__fill_2
XTAP_TAPCELL_ROW_16_203 VGND VPWR sky130_fd_sc_hd__tapvpwrvgnd_1
XFILLER_9_57 VGND VGND VPWR VPWR sky130_fd_sc_hd__fill_1
XFILLER_36_3 VGND VGND VPWR VPWR sky130_fd_sc_hd__decap_3
X_1303_ _1302_/A _1327_/B _1327_/C _1834_/A VGND VGND VPWR VPWR _1303_/X sky130_fd_sc_hd__o31a_2
XTAP_TAPCELL_ROW_47_372 VGND VPWR sky130_fd_sc_hd__tapvpwrvgnd_1
XTAP_TAPCELL_ROW_39_328 VGND VPWR sky130_fd_sc_hd__tapvpwrvgnd_1
X_1096_ _1095_/X _1092_/X _1146_/S VGND VGND VPWR VPWR _1096_/X sky130_fd_sc_hd__mux2_1
X_1234_ _2018_/Q _1315_/A _1290_/B VGND VGND VPWR VPWR _1254_/B sky130_fd_sc_hd__o21ai_2
X_1165_ _1222_/A _1159_/A _1160_/B VGND VGND VPWR VPWR _1166_/B sky130_fd_sc_hd__o21a_2
XFILLER_20_211 VGND VGND VPWR VPWR sky130_fd_sc_hd__fill_1
X_1998_ clkload4/A _1998_/D VGND VGND VPWR VPWR _1998_/Q sky130_fd_sc_hd__dfxtp_2
X_0949_ _2085_/Q _0950_/C VGND VGND VPWR VPWR _2085_/D sky130_fd_sc_hd__xor2_2
XFILLER_7_259 VGND VGND VPWR VPWR sky130_fd_sc_hd__decap_3
XFILLER_11_222 VGND VGND VPWR VPWR sky130_fd_sc_hd__fill_2
XFILLER_11_255 VGND VGND VPWR VPWR sky130_fd_sc_hd__decap_3
XTAP_TAPCELL_ROW_36_309 VGND VPWR sky130_fd_sc_hd__tapvpwrvgnd_1
XTAP_TAPCELL_ROW_44_353 VGND VPWR sky130_fd_sc_hd__tapvpwrvgnd_1
Xload_slew76 _1832_/A0 VGND VGND VPWR VPWR _1028_/B sky130_fd_sc_hd__buf_4
X_1852_ _1899_/CLK _1852_/D VGND VGND VPWR VPWR _1852_/Q sky130_fd_sc_hd__dfxtp_2
X_1921_ _2065_/CLK _1921_/D VGND VGND VPWR VPWR _1921_/Q sky130_fd_sc_hd__dfxtp_2
X_1783_ _1809_/A1 _2056_/Q _1811_/B1 _1782_/X VGND VGND VPWR VPWR _2057_/D sky130_fd_sc_hd__o211a_2
Xfanout9 _1292_/X VGND VGND VPWR VPWR _1327_/B sky130_fd_sc_hd__clkdlybuf4s25_1
XFILLER_29_108 VGND VGND VPWR VPWR sky130_fd_sc_hd__decap_3
XFILLER_40_306 VGND VGND VPWR VPWR sky130_fd_sc_hd__fill_2
X_1148_ _1181_/B _1181_/C _1181_/A VGND VGND VPWR VPWR _1277_/A sky130_fd_sc_hd__o21a_2
X_1217_ _1216_/A _1225_/A _1216_/B _1160_/B _1159_/A VGND VGND VPWR VPWR _1218_/B
+ sky130_fd_sc_hd__a32o_2
X_1079_ _1079_/A _1181_/A VGND VGND VPWR VPWR _1079_/Y sky130_fd_sc_hd__nand2_2
XTAP_TAPCELL_ROW_50_389 VGND VPWR sky130_fd_sc_hd__tapvpwrvgnd_1
XFILLER_20_45 VGND VGND VPWR VPWR sky130_fd_sc_hd__fill_2
XFILLER_45_20 VGND VGND VPWR VPWR sky130_fd_sc_hd__decap_3
XFILLER_28_174 VGND VGND VPWR VPWR sky130_fd_sc_hd__decap_3
XFILLER_6_36 VGND VGND VPWR VPWR sky130_fd_sc_hd__decap_3
XFILLER_20_6 VGND VGND VPWR VPWR sky130_fd_sc_hd__fill_1
X_1002_ _1003_/B _1449_/A VGND VGND VPWR VPWR _1464_/A sky130_fd_sc_hd__nand2_2
XFILLER_34_122 VGND VGND VPWR VPWR sky130_fd_sc_hd__fill_1
X_2051_ _2058_/CLK _2051_/D VGND VGND VPWR VPWR _2051_/Q sky130_fd_sc_hd__dfxtp_2
X_1835_ _1834_/Y hold184/X _1836_/S VGND VGND VPWR VPWR _2105_/D sky130_fd_sc_hd__mux2_1
X_1904_ clkload9/A _1904_/D VGND VGND VPWR VPWR _1904_/Q sky130_fd_sc_hd__dfxtp_2
X_1766_ _1806_/A _2049_/Q VGND VGND VPWR VPWR _1766_/X sky130_fd_sc_hd__or2_2
X_1697_ _1697_/A _1697_/B VGND VGND VPWR VPWR _1697_/Y sky130_fd_sc_hd__nand2_2
XFILLER_25_144 VGND VGND VPWR VPWR sky130_fd_sc_hd__fill_1
XFILLER_40_169 VGND VGND VPWR VPWR sky130_fd_sc_hd__decap_3
XFILLER_31_66 VGND VGND VPWR VPWR sky130_fd_sc_hd__decap_3
XFILLER_0_287 VGND VGND VPWR VPWR sky130_fd_sc_hd__decap_3
XFILLER_0_221 VGND VGND VPWR VPWR sky130_fd_sc_hd__decap_3
XFILLER_16_100 VGND VGND VPWR VPWR sky130_fd_sc_hd__decap_3
XFILLER_16_144 VGND VGND VPWR VPWR sky130_fd_sc_hd__decap_3
XFILLER_31_169 VGND VGND VPWR VPWR sky130_fd_sc_hd__decap_3
XFILLER_31_158 VGND VGND VPWR VPWR sky130_fd_sc_hd__fill_2
XFILLER_31_125 VGND VGND VPWR VPWR sky130_fd_sc_hd__decap_3
XFILLER_8_321 VGND VGND VPWR VPWR sky130_fd_sc_hd__decap_3
X_1551_ _1681_/A _1553_/B VGND VGND VPWR VPWR _1551_/Y sky130_fd_sc_hd__nor2_2
X_1482_ _1521_/B _1631_/A VGND VGND VPWR VPWR _1488_/S sky130_fd_sc_hd__or2_2
X_1620_ _1626_/A _1620_/B _1626_/C VGND VGND VPWR VPWR _1620_/X sky130_fd_sc_hd__and3_2
X_2103_ clkload9/A _2103_/D VGND VGND VPWR VPWR _2103_/Q sky130_fd_sc_hd__dfxtp_2
XFILLER_39_269 VGND VGND VPWR VPWR sky130_fd_sc_hd__fill_2
XFILLER_39_203 VGND VGND VPWR VPWR sky130_fd_sc_hd__decap_3
XTAP_TAPCELL_ROW_52_407 VGND VPWR sky130_fd_sc_hd__tapvpwrvgnd_1
X_2034_ _2035_/CLK _2034_/D VGND VGND VPWR VPWR _2034_/Q sky130_fd_sc_hd__dfxtp_2
XFILLER_30_191 VGND VGND VPWR VPWR sky130_fd_sc_hd__decap_3
X_1818_ _2093_/D _1817_/X _2073_/Q VGND VGND VPWR VPWR _1819_/B sky130_fd_sc_hd__mux2_1
XFILLER_22_169 VGND VGND VPWR VPWR sky130_fd_sc_hd__fill_1
X_1749_ _1770_/B _1764_/B _1748_/X _1749_/C1 VGND VGND VPWR VPWR _2040_/D sky130_fd_sc_hd__o211a_2
XFILLER_42_65 VGND VGND VPWR VPWR sky130_fd_sc_hd__fill_2
XFILLER_13_169 VGND VGND VPWR VPWR sky130_fd_sc_hd__fill_2
X_0982_ _2042_/Q _2041_/Q _2043_/Q VGND VGND VPWR VPWR a_selb1[3] sky130_fd_sc_hd__or3b_2
X_1465_ uo_out[3] _1464_/Y _1458_/Y VGND VGND VPWR VPWR _1915_/D sky130_fd_sc_hd__o21a_2
X_1534_ _1681_/A _1536_/B VGND VGND VPWR VPWR _1534_/Y sky130_fd_sc_hd__nor2_2
X_1603_ _1967_/Q _1772_/B _1603_/S VGND VGND VPWR VPWR _1967_/D sky130_fd_sc_hd__mux2_1
X_1396_ _1396_/A _1402_/B VGND VGND VPWR VPWR _1396_/Y sky130_fd_sc_hd__nand2_2
X_2017_ _2040_/CLK _2017_/D VGND VGND VPWR VPWR _2017_/Q sky130_fd_sc_hd__dfxtp_2
XFILLER_50_253 VGND VGND VPWR VPWR sky130_fd_sc_hd__fill_1
Xhold162 _2006_/Q VGND VGND VPWR VPWR hold162/X sky130_fd_sc_hd__dlygate4sd3_1
Xhold151 _2007_/Q VGND VGND VPWR VPWR hold151/X sky130_fd_sc_hd__dlygate4sd3_1
Xhold140 _1960_/Q VGND VGND VPWR VPWR hold140/X sky130_fd_sc_hd__dlygate4sd3_1
XFILLER_12_24 VGND VGND VPWR VPWR sky130_fd_sc_hd__decap_3
Xhold195 _2106_/Q VGND VGND VPWR VPWR hold195/X sky130_fd_sc_hd__dlygate4sd3_1
Xhold184 _2105_/Q VGND VGND VPWR VPWR hold184/X sky130_fd_sc_hd__dlygate4sd3_1
Xhold173 _1989_/Q VGND VGND VPWR VPWR hold173/X sky130_fd_sc_hd__dlygate4sd3_1
XTAP_TAPCELL_ROW_5_143 VGND VPWR sky130_fd_sc_hd__tapvpwrvgnd_1
XFILLER_18_206 VGND VGND VPWR VPWR sky130_fd_sc_hd__decap_3
XFILLER_41_220 VGND VGND VPWR VPWR sky130_fd_sc_hd__fill_1
XFILLER_37_98 VGND VGND VPWR VPWR sky130_fd_sc_hd__decap_3
XTAP_TAPCELL_ROW_28_267 VGND VPWR sky130_fd_sc_hd__tapvpwrvgnd_1
XFILLER_26_283 VGND VGND VPWR VPWR sky130_fd_sc_hd__fill_1
XFILLER_26_250 VGND VGND VPWR VPWR sky130_fd_sc_hd__fill_2
XFILLER_41_253 VGND VGND VPWR VPWR sky130_fd_sc_hd__decap_3
XFILLER_5_165 VGND VGND VPWR VPWR sky130_fd_sc_hd__decap_3
X_1181_ _1181_/A _1181_/B _1181_/C VGND VGND VPWR VPWR _1182_/B sky130_fd_sc_hd__nor3_2
X_1250_ _1099_/Y _1177_/Y _1178_/X _1249_/Y VGND VGND VPWR VPWR _1250_/X sky130_fd_sc_hd__a31o_2
XFILLER_32_286 VGND VGND VPWR VPWR sky130_fd_sc_hd__decap_3
XFILLER_32_253 VGND VGND VPWR VPWR sky130_fd_sc_hd__fill_2
XFILLER_17_272 VGND VGND VPWR VPWR sky130_fd_sc_hd__decap_3
X_0965_ _1908_/Q _1907_/Q VGND VGND VPWR VPWR _1447_/B sky130_fd_sc_hd__nor2_2
X_1448_ _1443_/Y _1447_/X _1446_/X _1831_/C VGND VGND VPWR VPWR _1908_/D sky130_fd_sc_hd__o211a_2
X_1517_ _2052_/Q _1521_/B VGND VGND VPWR VPWR _1626_/B sky130_fd_sc_hd__and2_2
X_1379_ _1404_/A _1381_/B VGND VGND VPWR VPWR _1379_/Y sky130_fd_sc_hd__nand2_2
XTAP_TAPCELL_ROW_2_124 VGND VPWR sky130_fd_sc_hd__tapvpwrvgnd_1
XFILLER_23_253 VGND VGND VPWR VPWR sky130_fd_sc_hd__decap_3
XFILLER_23_45 VGND VGND VPWR VPWR sky130_fd_sc_hd__fill_2
XFILLER_2_146 VGND VGND VPWR VPWR sky130_fd_sc_hd__decap_3
XFILLER_46_323 VGND VGND VPWR VPWR sky130_fd_sc_hd__fill_1
XFILLER_14_253 VGND VGND VPWR VPWR sky130_fd_sc_hd__decap_3
XTAP_TAPCELL_ROW_16_204 VGND VPWR sky130_fd_sc_hd__tapvpwrvgnd_1
Xfanout90 _1831_/C VGND VGND VPWR VPWR _1407_/C1 sky130_fd_sc_hd__clkdlybuf4s25_1
X_1302_ _1302_/A _1327_/B _1327_/C VGND VGND VPWR VPWR _1388_/A sky130_fd_sc_hd__or3_2
XFILLER_29_3 VGND VGND VPWR VPWR sky130_fd_sc_hd__fill_1
X_1233_ _1179_/X _1219_/X _1221_/X _1223_/Y _2019_/Q VGND VGND VPWR VPWR _1290_/B
+ sky130_fd_sc_hd__a221o_2
XTAP_TAPCELL_ROW_47_373 VGND VPWR sky130_fd_sc_hd__tapvpwrvgnd_1
XTAP_TAPCELL_ROW_39_329 VGND VPWR sky130_fd_sc_hd__tapvpwrvgnd_1
X_1095_ _1094_/X _1093_/X _1145_/S VGND VGND VPWR VPWR _1095_/X sky130_fd_sc_hd__mux2_1
X_1164_ _1158_/A _1102_/A _1160_/B VGND VGND VPWR VPWR _1166_/A sky130_fd_sc_hd__o21a_2
X_1997_ _2114_/CLK _1997_/D VGND VGND VPWR VPWR _1997_/Q sky130_fd_sc_hd__dfxtp_2
X_0948_ _0950_/C _0948_/B VGND VGND VPWR VPWR _2084_/D sky130_fd_sc_hd__nor2_2
XFILLER_20_278 VGND VGND VPWR VPWR sky130_fd_sc_hd__decap_3
XFILLER_47_109 VGND VGND VPWR VPWR sky130_fd_sc_hd__decap_3
XFILLER_34_44 VGND VGND VPWR VPWR sky130_fd_sc_hd__decap_3
XFILLER_11_201 VGND VGND VPWR VPWR sky130_fd_sc_hd__decap_3
XFILLER_11_289 VGND VGND VPWR VPWR sky130_fd_sc_hd__decap_3
XFILLER_38_109 VGND VGND VPWR VPWR sky130_fd_sc_hd__fill_1
X_1851_ hold198/X _1850_/A _1412_/Y VGND VGND VPWR VPWR _2117_/D sky130_fd_sc_hd__a21oi_2
XTAP_TAPCELL_ROW_44_354 VGND VPWR sky130_fd_sc_hd__tapvpwrvgnd_1
X_1920_ _2065_/CLK _1920_/D VGND VGND VPWR VPWR _1920_/Q sky130_fd_sc_hd__dfxtp_2
X_1782_ _2095_/Q _2057_/Q VGND VGND VPWR VPWR _1782_/X sky130_fd_sc_hd__or2_2
X_1216_ _1216_/A _1216_/B VGND VGND VPWR VPWR _1225_/B sky130_fd_sc_hd__nand2_2
X_1147_ _1147_/A _1147_/B VGND VGND VPWR VPWR _1181_/C sky130_fd_sc_hd__and2_2
X_1078_ _1100_/A _1077_/X _1211_/A1 VGND VGND VPWR VPWR _1257_/B sky130_fd_sc_hd__o21ai_2
XFILLER_20_24 VGND VGND VPWR VPWR sky130_fd_sc_hd__decap_3
XFILLER_20_35 VGND VGND VPWR VPWR sky130_fd_sc_hd__fill_1
XFILLER_29_77 VGND VGND VPWR VPWR sky130_fd_sc_hd__decap_3
XFILLER_28_197 VGND VGND VPWR VPWR sky130_fd_sc_hd__decap_3
XFILLER_43_189 VGND VGND VPWR VPWR sky130_fd_sc_hd__fill_2
XFILLER_3_252 VGND VGND VPWR VPWR sky130_fd_sc_hd__fill_1
XFILLER_6_26 VGND VGND VPWR VPWR sky130_fd_sc_hd__fill_2
X_2050_ _2068_/CLK _2050_/D VGND VGND VPWR VPWR _2050_/Q sky130_fd_sc_hd__dfxtp_2
X_1001_ _1003_/B _1449_/A VGND VGND VPWR VPWR _1001_/X sky130_fd_sc_hd__and2_2
XFILLER_19_175 VGND VGND VPWR VPWR sky130_fd_sc_hd__decap_3
X_1903_ _2115_/CLK _1903_/D VGND VGND VPWR VPWR _1903_/Q sky130_fd_sc_hd__dfxtp_2
X_1834_ _1834_/A _1840_/B VGND VGND VPWR VPWR _1834_/Y sky130_fd_sc_hd__nor2_2
X_1765_ _2060_/Q _1764_/B _1764_/Y _1824_/A VGND VGND VPWR VPWR _2048_/D sky130_fd_sc_hd__o211a_2
X_1696_ _2053_/Q _1697_/B _1695_/Y _1749_/C1 VGND VGND VPWR VPWR _2016_/D sky130_fd_sc_hd__o211a_2
XFILLER_25_189 VGND VGND VPWR VPWR sky130_fd_sc_hd__fill_2
XFILLER_25_134 VGND VGND VPWR VPWR sky130_fd_sc_hd__fill_1
XFILLER_13_307 VGND VGND VPWR VPWR sky130_fd_sc_hd__decap_3
XFILLER_15_24 VGND VGND VPWR VPWR sky130_fd_sc_hd__decap_3
XFILLER_15_68 VGND VGND VPWR VPWR sky130_fd_sc_hd__fill_1
XFILLER_31_137 VGND VGND VPWR VPWR sky130_fd_sc_hd__fill_2
X_1550_ hold138/X _1546_/X _1549_/Y VGND VGND VPWR VPWR _1937_/D sky130_fd_sc_hd__a21o_2
X_1481_ _2070_/Q _1481_/B VGND VGND VPWR VPWR _1631_/A sky130_fd_sc_hd__or2_2
X_2033_ _2035_/CLK _2033_/D VGND VGND VPWR VPWR _2033_/Q sky130_fd_sc_hd__dfxtp_2
X_2102_ clkload9/A _2102_/D VGND VGND VPWR VPWR _2102_/Q sky130_fd_sc_hd__dfxtp_2
XFILLER_30_170 VGND VGND VPWR VPWR sky130_fd_sc_hd__decap_3
X_1748_ _2040_/Q _1754_/B VGND VGND VPWR VPWR _1748_/X sky130_fd_sc_hd__or2_2
X_1817_ _2077_/Q _2076_/Q _1825_/B _2093_/Q _1816_/A VGND VGND VPWR VPWR _1817_/X
+ sky130_fd_sc_hd__a32o_2
X_1679_ _1679_/A _1683_/B VGND VGND VPWR VPWR _1679_/Y sky130_fd_sc_hd__nor2_2
XFILLER_13_104 VGND VGND VPWR VPWR sky130_fd_sc_hd__fill_1
XFILLER_42_88 VGND VGND VPWR VPWR sky130_fd_sc_hd__fill_1
XFILLER_13_148 VGND VGND VPWR VPWR sky130_fd_sc_hd__decap_3
XPHY_EDGE_ROW_48_Left_101 VGND VGND VPWR VPWR sky130_fd_sc_hd__decap_3
XFILLER_29_281 VGND VGND VPWR VPWR sky130_fd_sc_hd__decap_3
X_0981_ a_selb1[2] VGND VGND VPWR VPWR a_sel1[2] sky130_fd_sc_hd__inv_2
XFILLER_8_141 VGND VGND VPWR VPWR sky130_fd_sc_hd__fill_1
X_1602_ _1966_/Q _2051_/Q _1603_/S VGND VGND VPWR VPWR _1966_/D sky130_fd_sc_hd__mux2_1
X_1464_ _1464_/A _1464_/B VGND VGND VPWR VPWR _1464_/Y sky130_fd_sc_hd__nor2_2
X_1533_ hold121/X _1529_/X _1532_/Y VGND VGND VPWR VPWR _1929_/D sky130_fd_sc_hd__a21o_2
X_1395_ _1893_/Q _1402_/B _1394_/Y _1395_/C1 VGND VGND VPWR VPWR _1893_/D sky130_fd_sc_hd__o211a_2
XFILLER_27_218 VGND VGND VPWR VPWR sky130_fd_sc_hd__decap_3
X_2016_ _2040_/CLK _2016_/D VGND VGND VPWR VPWR _2016_/Q sky130_fd_sc_hd__dfxtp_2
XFILLER_50_243 VGND VGND VPWR VPWR sky130_fd_sc_hd__fill_1
XFILLER_35_295 VGND VGND VPWR VPWR sky130_fd_sc_hd__fill_2
XFILLER_12_14 VGND VGND VPWR VPWR sky130_fd_sc_hd__fill_1
Xhold152 _1934_/Q VGND VGND VPWR VPWR hold152/X sky130_fd_sc_hd__dlygate4sd3_1
Xhold174 _2108_/Q VGND VGND VPWR VPWR hold174/X sky130_fd_sc_hd__dlygate4sd3_1
Xhold141 _1957_/Q VGND VGND VPWR VPWR hold141/X sky130_fd_sc_hd__dlygate4sd3_1
Xhold163 _1970_/Q VGND VGND VPWR VPWR hold163/X sky130_fd_sc_hd__dlygate4sd3_1
Xhold185 _1969_/Q VGND VGND VPWR VPWR hold185/X sky130_fd_sc_hd__dlygate4sd3_1
Xhold130 _1972_/Q VGND VGND VPWR VPWR hold130/X sky130_fd_sc_hd__dlygate4sd3_1
Xhold196 _1926_/Q VGND VGND VPWR VPWR hold196/X sky130_fd_sc_hd__dlygate4sd3_1
XFILLER_37_66 VGND VGND VPWR VPWR sky130_fd_sc_hd__decap_3
XTAP_TAPCELL_ROW_28_268 VGND VPWR sky130_fd_sc_hd__tapvpwrvgnd_1
XFILLER_5_111 VGND VGND VPWR VPWR sky130_fd_sc_hd__fill_1
Xclkbuf_leaf_21_clk clkbuf_leaf_2_clk/A VGND VGND VPWR VPWR clkload1/A sky130_fd_sc_hd__clkbuf_8
XFILLER_5_177 VGND VGND VPWR VPWR sky130_fd_sc_hd__decap_3
X_1180_ _1180_/A _1180_/B _1180_/C VGND VGND VPWR VPWR _1180_/X sky130_fd_sc_hd__and3_2
XFILLER_17_240 VGND VGND VPWR VPWR sky130_fd_sc_hd__fill_2
Xclkbuf_leaf_12_clk clkbuf_leaf_3_clk/A VGND VGND VPWR VPWR _2115_/CLK sky130_fd_sc_hd__clkbuf_8
X_0964_ _2092_/Q _0964_/B VGND VGND VPWR VPWR _2092_/D sky130_fd_sc_hd__xor2_2
X_1516_ _2052_/Q _1516_/B VGND VGND VPWR VPWR _1683_/A sky130_fd_sc_hd__nand2_2
X_1447_ _1911_/Q _1447_/B VGND VGND VPWR VPWR _1447_/X sky130_fd_sc_hd__and2_2
X_1378_ _1885_/Q _1377_/B _1377_/Y _1403_/C1 VGND VGND VPWR VPWR _1885_/D sky130_fd_sc_hd__o211a_2
XTAP_TAPCELL_ROW_2_125 VGND VPWR sky130_fd_sc_hd__tapvpwrvgnd_1
XTAP_TAPCELL_ROW_25_249 VGND VPWR sky130_fd_sc_hd__tapvpwrvgnd_1
XFILLER_23_265 VGND VGND VPWR VPWR sky130_fd_sc_hd__decap_3
XTAP_TAPCELL_ROW_33_293 VGND VPWR sky130_fd_sc_hd__tapvpwrvgnd_1
XFILLER_23_298 VGND VGND VPWR VPWR sky130_fd_sc_hd__fill_2
XFILLER_23_57 VGND VGND VPWR VPWR sky130_fd_sc_hd__decap_3
XFILLER_2_158 VGND VGND VPWR VPWR sky130_fd_sc_hd__decap_3
Xfanout91 _1837_/C VGND VGND VPWR VPWR _1831_/C sky130_fd_sc_hd__clkdlybuf4s25_1
Xfanout80 _1811_/B1 VGND VGND VPWR VPWR _1805_/B1 sky130_fd_sc_hd__clkdlybuf4s25_1
XFILLER_14_232 VGND VGND VPWR VPWR sky130_fd_sc_hd__decap_3
XFILLER_14_265 VGND VGND VPWR VPWR sky130_fd_sc_hd__decap_3
XFILLER_14_298 VGND VGND VPWR VPWR sky130_fd_sc_hd__decap_3
XFILLER_43_6 VGND VGND VPWR VPWR sky130_fd_sc_hd__fill_2
XPHY_EDGE_ROW_24_Left_77 VGND VGND VPWR VPWR sky130_fd_sc_hd__decap_3
X_1301_ _1853_/Q _1310_/A _1300_/Y _1723_/C1 VGND VGND VPWR VPWR _1853_/D sky130_fd_sc_hd__o211a_2
X_1232_ _2019_/Q _1318_/A _1315_/A _2018_/Q VGND VGND VPWR VPWR _1290_/A sky130_fd_sc_hd__a22o_2
Xclkbuf_leaf_1_clk clkbuf_leaf_2_clk/A VGND VGND VPWR VPWR clkload0/A sky130_fd_sc_hd__clkbuf_8
XTAP_TAPCELL_ROW_47_374 VGND VPWR sky130_fd_sc_hd__tapvpwrvgnd_1
X_1094_ _1919_/Q _1923_/Q _1927_/Q _1931_/Q _1144_/S0 _1144_/S1 VGND VGND VPWR VPWR
+ _1094_/X sky130_fd_sc_hd__mux4_2
X_1163_ _1163_/A _1267_/A _1163_/C _1163_/D VGND VGND VPWR VPWR _1167_/A sky130_fd_sc_hd__nand4_2
X_1996_ clkload4/A _1996_/D VGND VGND VPWR VPWR _1996_/Q sky130_fd_sc_hd__dfxtp_2
X_0947_ _2084_/Q _0947_/B VGND VGND VPWR VPWR _0948_/B sky130_fd_sc_hd__nor2_2
XFILLER_11_213 VGND VGND VPWR VPWR sky130_fd_sc_hd__decap_3
XFILLER_7_206 VGND VGND VPWR VPWR sky130_fd_sc_hd__decap_3
XFILLER_7_239 VGND VGND VPWR VPWR sky130_fd_sc_hd__decap_3
XFILLER_11_268 VGND VGND VPWR VPWR sky130_fd_sc_hd__decap_3
Xclkload0 clkload0/A VGND VGND VPWR VPWR clkload0/X sky130_fd_sc_hd__clkbuf_4
XTAP_TAPCELL_ROW_21_230 VGND VPWR sky130_fd_sc_hd__tapvpwrvgnd_1
XTAP_TAPCELL_ROW_44_355 VGND VPWR sky130_fd_sc_hd__tapvpwrvgnd_1
X_1850_ _1850_/A _1850_/B VGND VGND VPWR VPWR _2116_/D sky130_fd_sc_hd__nor2_2
X_1781_ _1809_/A1 _2055_/Q _1789_/B1 _1780_/X VGND VGND VPWR VPWR _2056_/D sky130_fd_sc_hd__o211a_2
X_1146_ _1145_/X _1142_/X _1146_/S VGND VGND VPWR VPWR _1147_/B sky130_fd_sc_hd__mux2_1
XFILLER_1_60 VGND VGND VPWR VPWR sky130_fd_sc_hd__fill_1
X_1215_ _1163_/A _1267_/A _1163_/C _1166_/A VGND VGND VPWR VPWR _1216_/B sky130_fd_sc_hd__a31o_2
X_1077_ _1201_/A _1208_/A _1208_/B VGND VGND VPWR VPWR _1077_/X sky130_fd_sc_hd__or3_2
X_1979_ _2077_/CLK _1979_/D VGND VGND VPWR VPWR _1979_/Q sky130_fd_sc_hd__dfxtp_2
XFILLER_43_113 VGND VGND VPWR VPWR sky130_fd_sc_hd__decap_3
XFILLER_29_89 VGND VGND VPWR VPWR sky130_fd_sc_hd__fill_1
XFILLER_31_319 VGND VGND VPWR VPWR sky130_fd_sc_hd__decap_3
X_1000_ _1834_/A _1449_/A VGND VGND VPWR VPWR _1460_/A sky130_fd_sc_hd__nand2_2
XFILLER_19_143 VGND VGND VPWR VPWR sky130_fd_sc_hd__decap_3
XFILLER_19_165 VGND VGND VPWR VPWR sky130_fd_sc_hd__decap_3
X_1902_ clkload8/A _1902_/D VGND VGND VPWR VPWR _1902_/Q sky130_fd_sc_hd__dfxtp_2
XFILLER_42_190 VGND VGND VPWR VPWR sky130_fd_sc_hd__fill_1
XFILLER_19_187 VGND VGND VPWR VPWR sky130_fd_sc_hd__decap_3
X_1833_ _1832_/X _2104_/Q _1836_/S VGND VGND VPWR VPWR _2104_/D sky130_fd_sc_hd__mux2_1
X_1764_ _1764_/A _1764_/B VGND VGND VPWR VPWR _1764_/Y sky130_fd_sc_hd__nand2_2
XPHY_EDGE_ROW_27_Left_80 VGND VGND VPWR VPWR sky130_fd_sc_hd__decap_3
X_1695_ _1695_/A _1697_/B VGND VGND VPWR VPWR _1695_/Y sky130_fd_sc_hd__nand2_2
X_1129_ _1136_/A _1129_/B _1129_/C VGND VGND VPWR VPWR _1129_/X sky130_fd_sc_hd__or3_2
XFILLER_25_124 VGND VGND VPWR VPWR sky130_fd_sc_hd__fill_2
XPHY_EDGE_ROW_11_Left_64 VGND VGND VPWR VPWR sky130_fd_sc_hd__decap_3
XFILLER_40_138 VGND VGND VPWR VPWR sky130_fd_sc_hd__fill_2
XFILLER_31_79 VGND VGND VPWR VPWR sky130_fd_sc_hd__decap_3
XFILLER_31_57 VGND VGND VPWR VPWR sky130_fd_sc_hd__decap_3
XFILLER_0_267 VGND VGND VPWR VPWR sky130_fd_sc_hd__fill_2
XFILLER_0_245 VGND VGND VPWR VPWR sky130_fd_sc_hd__decap_3
XFILLER_16_124 VGND VGND VPWR VPWR sky130_fd_sc_hd__decap_3
XPHY_EDGE_ROW_19_Right_19 VGND VGND VPWR VPWR sky130_fd_sc_hd__decap_3
XPHY_EDGE_ROW_28_Right_28 VGND VGND VPWR VPWR sky130_fd_sc_hd__decap_3
X_1480_ _2072_/Q _1480_/B _2071_/Q _2069_/Q VGND VGND VPWR VPWR _1481_/B sky130_fd_sc_hd__or4b_2
X_2032_ _2036_/CLK _2032_/D VGND VGND VPWR VPWR _2032_/Q sky130_fd_sc_hd__dfxtp_2
X_2101_ clkload8/A input7/X VGND VGND VPWR VPWR _2101_/Q sky130_fd_sc_hd__dfxtp_2
XPHY_EDGE_ROW_37_Right_37 VGND VGND VPWR VPWR sky130_fd_sc_hd__decap_3
XPHY_EDGE_ROW_46_Right_46 VGND VGND VPWR VPWR sky130_fd_sc_hd__decap_3
X_1678_ hold145/X _1676_/X _1677_/Y VGND VGND VPWR VPWR _2008_/D sky130_fd_sc_hd__a21o_2
X_1747_ _1506_/A _1764_/B _1746_/X _1749_/C1 VGND VGND VPWR VPWR _2039_/D sky130_fd_sc_hd__o211a_2
X_1816_ _1816_/A _1816_/B VGND VGND VPWR VPWR _1825_/B sky130_fd_sc_hd__nor2_2
XFILLER_26_57 VGND VGND VPWR VPWR sky130_fd_sc_hd__decap_3
XFILLER_13_116 VGND VGND VPWR VPWR sky130_fd_sc_hd__decap_3
XFILLER_29_293 VGND VGND VPWR VPWR sky130_fd_sc_hd__fill_1
XFILLER_44_263 VGND VGND VPWR VPWR sky130_fd_sc_hd__decap_3
X_0980_ _2043_/Q _2042_/Q _2041_/Q VGND VGND VPWR VPWR a_selb1[2] sky130_fd_sc_hd__nand3b_2
XTAP_TAPCELL_ROW_14_188 VGND VPWR sky130_fd_sc_hd__tapvpwrvgnd_1
X_1532_ _1679_/A _1536_/B VGND VGND VPWR VPWR _1532_/Y sky130_fd_sc_hd__nor2_2
XFILLER_8_197 VGND VGND VPWR VPWR sky130_fd_sc_hd__fill_2
XFILLER_12_182 VGND VGND VPWR VPWR sky130_fd_sc_hd__fill_1
X_1601_ hold171/X _1506_/A _1603_/S VGND VGND VPWR VPWR _1965_/D sky130_fd_sc_hd__mux2_1
X_1463_ uo_out[2] _1462_/Y _1458_/Y VGND VGND VPWR VPWR _1914_/D sky130_fd_sc_hd__o21a_2
X_1394_ _1394_/A _1402_/B VGND VGND VPWR VPWR _1394_/Y sky130_fd_sc_hd__nand2_2
XFILLER_35_274 VGND VGND VPWR VPWR sky130_fd_sc_hd__decap_3
X_2015_ _2068_/CLK _2015_/D VGND VGND VPWR VPWR _2015_/Q sky130_fd_sc_hd__dfxtp_2
Xhold175 _2113_/Q VGND VGND VPWR VPWR hold175/X sky130_fd_sc_hd__dlygate4sd3_1
Xhold142 _2002_/Q VGND VGND VPWR VPWR hold142/X sky130_fd_sc_hd__dlygate4sd3_1
Xhold120 _1946_/Q VGND VGND VPWR VPWR hold120/X sky130_fd_sc_hd__dlygate4sd3_1
Xhold186 _1918_/Q VGND VGND VPWR VPWR hold186/X sky130_fd_sc_hd__dlygate4sd3_1
Xhold131 _1963_/Q VGND VGND VPWR VPWR hold131/X sky130_fd_sc_hd__dlygate4sd3_1
Xhold153 _1981_/Q VGND VGND VPWR VPWR hold153/X sky130_fd_sc_hd__dlygate4sd3_1
Xhold164 _1978_/Q VGND VGND VPWR VPWR hold164/X sky130_fd_sc_hd__dlygate4sd3_1
Xhold197 _1974_/Q VGND VGND VPWR VPWR hold197/X sky130_fd_sc_hd__dlygate4sd3_1
XFILLER_41_211 VGND VGND VPWR VPWR sky130_fd_sc_hd__fill_1
XTAP_TAPCELL_ROW_28_269 VGND VPWR sky130_fd_sc_hd__tapvpwrvgnd_1
XFILLER_26_274 VGND VGND VPWR VPWR sky130_fd_sc_hd__decap_3
XFILLER_26_241 VGND VGND VPWR VPWR sky130_fd_sc_hd__fill_1
XFILLER_32_200 VGND VGND VPWR VPWR sky130_fd_sc_hd__decap_3
XFILLER_32_299 VGND VGND VPWR VPWR sky130_fd_sc_hd__decap_3
XFILLER_32_277 VGND VGND VPWR VPWR sky130_fd_sc_hd__decap_3
XFILLER_32_266 VGND VGND VPWR VPWR sky130_fd_sc_hd__decap_3
X_0963_ _0964_/B _0963_/B VGND VGND VPWR VPWR _2091_/D sky130_fd_sc_hd__and2b_2
X_1515_ _1772_/B _1598_/A VGND VGND VPWR VPWR _1515_/X sky130_fd_sc_hd__and2_2
X_1446_ _2134_/A _1443_/B _1908_/Q VGND VGND VPWR VPWR _1446_/X sky130_fd_sc_hd__a21o_2
X_1377_ _1402_/A _1377_/B VGND VGND VPWR VPWR _1377_/Y sky130_fd_sc_hd__nand2_2
XTAP_TAPCELL_ROW_2_126 VGND VPWR sky130_fd_sc_hd__tapvpwrvgnd_1
XTAP_TAPCELL_ROW_33_294 VGND VPWR sky130_fd_sc_hd__tapvpwrvgnd_1
XFILLER_3_6 VGND VGND VPWR VPWR sky130_fd_sc_hd__decap_3
Xfanout92 input2/X VGND VGND VPWR VPWR _1837_/C sky130_fd_sc_hd__clkdlybuf4s25_1
Xfanout81 _1824_/A VGND VGND VPWR VPWR _1811_/B1 sky130_fd_sc_hd__clkdlybuf4s25_1
XFILLER_14_288 VGND VGND VPWR VPWR sky130_fd_sc_hd__decap_3
XFILLER_36_6 VGND VGND VPWR VPWR sky130_fd_sc_hd__fill_2
X_1300_ _1310_/A _1386_/A VGND VGND VPWR VPWR _1300_/Y sky130_fd_sc_hd__nand2_2
X_1162_ _1162_/A VGND VGND VPWR VPWR _1163_/D sky130_fd_sc_hd__inv_2
X_1231_ _1266_/B1 _1228_/X _1230_/X _1279_/A1 _1226_/X VGND VGND VPWR VPWR _1315_/A
+ sky130_fd_sc_hd__a32o_2
XFILLER_52_306 VGND VGND VPWR VPWR sky130_fd_sc_hd__fill_2
X_1093_ _1935_/Q _1939_/Q _1943_/Q _1947_/Q _1143_/S0 _1141_/S1 VGND VGND VPWR VPWR
+ _1093_/X sky130_fd_sc_hd__mux4_2
X_1995_ _2001_/CLK _1995_/D VGND VGND VPWR VPWR _1995_/Q sky130_fd_sc_hd__dfxtp_2
X_0946_ _2084_/Q _0947_/B VGND VGND VPWR VPWR _0950_/C sky130_fd_sc_hd__and2_2
XFILLER_9_281 VGND VGND VPWR VPWR sky130_fd_sc_hd__decap_3
X_1429_ _1830_/D _1427_/A _1428_/X VGND VGND VPWR VPWR _1904_/D sky130_fd_sc_hd__a21oi_2
XTAP_TAPCELL_ROW_38_320 VGND VPWR sky130_fd_sc_hd__tapvpwrvgnd_1
XPHY_EDGE_ROW_41_Left_94 VGND VGND VPWR VPWR sky130_fd_sc_hd__decap_3
XFILLER_7_218 VGND VGND VPWR VPWR sky130_fd_sc_hd__decap_3
XFILLER_11_225 VGND VGND VPWR VPWR sky130_fd_sc_hd__decap_3
XFILLER_11_258 VGND VGND VPWR VPWR sky130_fd_sc_hd__decap_3
Xclkload1 clkload1/A VGND VGND VPWR VPWR clkload1/X sky130_fd_sc_hd__clkbuf_4
XTAP_TAPCELL_ROW_21_231 VGND VPWR sky130_fd_sc_hd__tapvpwrvgnd_1
XFILLER_50_89 VGND VGND VPWR VPWR sky130_fd_sc_hd__fill_1
XFILLER_1_3 VGND VGND VPWR VPWR sky130_fd_sc_hd__decap_3
XTAP_TAPCELL_ROW_44_356 VGND VPWR sky130_fd_sc_hd__tapvpwrvgnd_1
X_1780_ _1808_/A _2056_/Q VGND VGND VPWR VPWR _1780_/X sky130_fd_sc_hd__or2_2
XFILLER_10_280 VGND VGND VPWR VPWR sky130_fd_sc_hd__decap_3
X_1145_ _1144_/X _1143_/X _1145_/S VGND VGND VPWR VPWR _1145_/X sky130_fd_sc_hd__mux2_1
X_1214_ _2020_/Q _1321_/A VGND VGND VPWR VPWR _1255_/C sky130_fd_sc_hd__nor2_2
XFILLER_52_169 VGND VGND VPWR VPWR sky130_fd_sc_hd__decap_3
X_1076_ _1208_/A _1208_/B VGND VGND VPWR VPWR _1200_/B sky130_fd_sc_hd__or2_2
X_0929_ _1906_/Q VGND VGND VPWR VPWR _0929_/Y sky130_fd_sc_hd__inv_2
X_1978_ clkload0/A _1978_/D VGND VGND VPWR VPWR _1978_/Q sky130_fd_sc_hd__dfxtp_2
XFILLER_29_57 VGND VGND VPWR VPWR sky130_fd_sc_hd__decap_3
XFILLER_28_100 VGND VGND VPWR VPWR sky130_fd_sc_hd__fill_2
XFILLER_45_23 VGND VGND VPWR VPWR sky130_fd_sc_hd__fill_1
XFILLER_28_177 VGND VGND VPWR VPWR sky130_fd_sc_hd__fill_2
XTAP_TAPCELL_ROW_41_337 VGND VPWR sky130_fd_sc_hd__tapvpwrvgnd_1
XFILLER_6_39 VGND VGND VPWR VPWR sky130_fd_sc_hd__decap_3
XFILLER_3_243 VGND VGND VPWR VPWR sky130_fd_sc_hd__decap_3
XFILLER_19_122 VGND VGND VPWR VPWR sky130_fd_sc_hd__decap_3
X_1832_ _1832_/A0 input6/X _1840_/B VGND VGND VPWR VPWR _1832_/X sky130_fd_sc_hd__mux2_1
X_1901_ clkload8/A _1901_/D VGND VGND VPWR VPWR _1901_/Q sky130_fd_sc_hd__dfxtp_2
XFILLER_42_180 VGND VGND VPWR VPWR sky130_fd_sc_hd__fill_2
XFILLER_34_158 VGND VGND VPWR VPWR sky130_fd_sc_hd__decap_3
XFILLER_30_320 VGND VGND VPWR VPWR sky130_fd_sc_hd__decap_3
X_1763_ _2059_/Q _1764_/B _1762_/X _1789_/B1 VGND VGND VPWR VPWR _2047_/D sky130_fd_sc_hd__o211a_2
X_1694_ _1772_/B _1709_/B _1693_/X _1749_/C1 VGND VGND VPWR VPWR _2015_/D sky130_fd_sc_hd__o211a_2
X_1128_ _1981_/Q _1137_/A2 _1441_/B _1993_/Q VGND VGND VPWR VPWR _1129_/C sky130_fd_sc_hd__a22o_2
XFILLER_25_169 VGND VGND VPWR VPWR sky130_fd_sc_hd__decap_3
X_1059_ _1222_/B _1228_/A _1222_/A VGND VGND VPWR VPWR _1210_/B sky130_fd_sc_hd__o21ai_2
XFILLER_31_69 VGND VGND VPWR VPWR sky130_fd_sc_hd__decap_3
XFILLER_0_279 VGND VGND VPWR VPWR sky130_fd_sc_hd__fill_1
XFILLER_16_103 VGND VGND VPWR VPWR sky130_fd_sc_hd__fill_2
XFILLER_31_128 VGND VGND VPWR VPWR sky130_fd_sc_hd__decap_3
XFILLER_21_80 VGND VGND VPWR VPWR sky130_fd_sc_hd__decap_3
X_2100_ clkload8/A _2100_/D VGND VGND VPWR VPWR _2100_/Q sky130_fd_sc_hd__dfxtp_2
XFILLER_39_206 VGND VGND VPWR VPWR sky130_fd_sc_hd__fill_2
X_2031_ _2035_/CLK _2031_/D VGND VGND VPWR VPWR _2031_/Q sky130_fd_sc_hd__dfxtp_2
XFILLER_30_194 VGND VGND VPWR VPWR sky130_fd_sc_hd__fill_2
X_1815_ _2075_/Q _2074_/Q _2073_/Q VGND VGND VPWR VPWR _1816_/B sky130_fd_sc_hd__nand3_2
XFILLER_15_180 VGND VGND VPWR VPWR sky130_fd_sc_hd__decap_3
X_1677_ _1677_/A _1683_/B VGND VGND VPWR VPWR _1677_/Y sky130_fd_sc_hd__nor2_2
X_1746_ _2039_/Q _1754_/B VGND VGND VPWR VPWR _1746_/X sky130_fd_sc_hd__or2_2
XFILLER_38_261 VGND VGND VPWR VPWR sky130_fd_sc_hd__fill_1
XFILLER_26_69 VGND VGND VPWR VPWR sky130_fd_sc_hd__decap_3
XFILLER_44_242 VGND VGND VPWR VPWR sky130_fd_sc_hd__fill_2
XTAP_TAPCELL_ROW_14_189 VGND VPWR sky130_fd_sc_hd__tapvpwrvgnd_1
X_1462_ _1462_/A _1464_/B VGND VGND VPWR VPWR _1462_/Y sky130_fd_sc_hd__nor2_2
X_1531_ hold133/X _1529_/X _1530_/Y VGND VGND VPWR VPWR _1928_/D sky130_fd_sc_hd__a21o_2
X_1600_ hold189/X _1521_/A _1603_/S VGND VGND VPWR VPWR _1964_/D sky130_fd_sc_hd__mux2_1
X_1393_ _1892_/Q _1402_/B _1392_/Y _1395_/C1 VGND VGND VPWR VPWR _1892_/D sky130_fd_sc_hd__o211a_2
X_2014_ clkload1/A _2014_/D VGND VGND VPWR VPWR _2014_/Q sky130_fd_sc_hd__dfxtp_2
Xhold110 _2098_/Q VGND VGND VPWR VPWR _2099_/D sky130_fd_sc_hd__dlygate4sd3_1
XFILLER_10_109 VGND VGND VPWR VPWR sky130_fd_sc_hd__fill_1
XFILLER_12_27 VGND VGND VPWR VPWR sky130_fd_sc_hd__fill_1
X_1729_ _2031_/Q _2032_/Q _2033_/Q VGND VGND VPWR VPWR _1731_/C sky130_fd_sc_hd__a21o_2
Xhold154 _1940_/Q VGND VGND VPWR VPWR hold154/X sky130_fd_sc_hd__dlygate4sd3_1
Xhold143 _1943_/Q VGND VGND VPWR VPWR hold143/X sky130_fd_sc_hd__dlygate4sd3_1
Xhold187 _1996_/Q VGND VGND VPWR VPWR hold187/X sky130_fd_sc_hd__dlygate4sd3_1
Xhold198 _1901_/Q VGND VGND VPWR VPWR hold198/X sky130_fd_sc_hd__dlygate4sd3_1
Xhold176 _1992_/Q VGND VGND VPWR VPWR hold176/X sky130_fd_sc_hd__dlygate4sd3_1
Xhold121 _1929_/Q VGND VGND VPWR VPWR hold121/X sky130_fd_sc_hd__dlygate4sd3_1
Xhold165 _1948_/Q VGND VGND VPWR VPWR hold165/X sky130_fd_sc_hd__dlygate4sd3_1
Xhold132 _1976_/Q VGND VGND VPWR VPWR hold132/X sky130_fd_sc_hd__dlygate4sd3_1
XFILLER_37_57 VGND VGND VPWR VPWR sky130_fd_sc_hd__decap_3
XFILLER_26_253 VGND VGND VPWR VPWR sky130_fd_sc_hd__fill_1
XFILLER_18_209 VGND VGND VPWR VPWR sky130_fd_sc_hd__fill_1
XFILLER_41_278 VGND VGND VPWR VPWR sky130_fd_sc_hd__fill_2
XFILLER_5_113 VGND VGND VPWR VPWR sky130_fd_sc_hd__fill_1
XFILLER_17_275 VGND VGND VPWR VPWR sky130_fd_sc_hd__decap_3
XFILLER_17_297 VGND VGND VPWR VPWR sky130_fd_sc_hd__decap_3
XFILLER_32_289 VGND VGND VPWR VPWR sky130_fd_sc_hd__fill_2
X_0962_ _2090_/Q _0961_/C _2091_/Q VGND VGND VPWR VPWR _0963_/B sky130_fd_sc_hd__a21o_2
X_1445_ _0967_/D _1443_/B _1444_/Y _1830_/C VGND VGND VPWR VPWR _1907_/D sky130_fd_sc_hd__a211oi_2
X_1514_ _1923_/Q _1514_/B VGND VGND VPWR VPWR _1514_/X sky130_fd_sc_hd__and2_2
XTAP_TAPCELL_ROW_10_170 VGND VPWR sky130_fd_sc_hd__tapvpwrvgnd_1
X_1376_ _1884_/Q _1381_/B _1375_/Y _1403_/C1 VGND VGND VPWR VPWR _1884_/D sky130_fd_sc_hd__o211a_2
XTAP_TAPCELL_ROW_2_127 VGND VPWR sky130_fd_sc_hd__tapvpwrvgnd_1
XTAP_TAPCELL_ROW_33_295 VGND VPWR sky130_fd_sc_hd__tapvpwrvgnd_1
XFILLER_23_256 VGND VGND VPWR VPWR sky130_fd_sc_hd__decap_3
XFILLER_2_149 VGND VGND VPWR VPWR sky130_fd_sc_hd__decap_3
XFILLER_14_256 VGND VGND VPWR VPWR sky130_fd_sc_hd__decap_3
Xfanout82 _1736_/B VGND VGND VPWR VPWR _1824_/A sky130_fd_sc_hd__clkdlybuf4s25_1
Xfanout60 _2051_/Q VGND VGND VPWR VPWR _1770_/B sky130_fd_sc_hd__clkdlybuf4s25_1
Xfanout93 input1/X VGND VGND VPWR VPWR fanout93/X sky130_fd_sc_hd__clkdlybuf4s25_1
XFILLER_14_278 VGND VGND VPWR VPWR sky130_fd_sc_hd__decap_3
XFILLER_49_186 VGND VGND VPWR VPWR sky130_fd_sc_hd__decap_3
X_1092_ _1091_/X _1090_/X _1145_/S VGND VGND VPWR VPWR _1092_/X sky130_fd_sc_hd__mux2_1
X_1230_ _1230_/A _1264_/B _1229_/X VGND VGND VPWR VPWR _1230_/X sky130_fd_sc_hd__or3b_2
X_1161_ _1249_/A _1225_/A _1218_/A VGND VGND VPWR VPWR _1162_/A sky130_fd_sc_hd__nand3_2
X_1994_ _2001_/CLK _1994_/D VGND VGND VPWR VPWR _1994_/Q sky130_fd_sc_hd__dfxtp_2
XFILLER_20_248 VGND VGND VPWR VPWR sky130_fd_sc_hd__decap_3
XTAP_TAPCELL_ROW_30_276 VGND VPWR sky130_fd_sc_hd__tapvpwrvgnd_1
X_0945_ _0947_/B _0945_/B VGND VGND VPWR VPWR _2083_/D sky130_fd_sc_hd__nor2_2
X_1428_ _1846_/D _1427_/Y _1830_/C VGND VGND VPWR VPWR _1428_/X sky130_fd_sc_hd__a21o_2
XFILLER_28_304 VGND VGND VPWR VPWR sky130_fd_sc_hd__decap_3
XTAP_TAPCELL_ROW_38_321 VGND VPWR sky130_fd_sc_hd__tapvpwrvgnd_1
X_1359_ _1384_/A _1365_/B VGND VGND VPWR VPWR _1359_/Y sky130_fd_sc_hd__nand2_2
XFILLER_34_47 VGND VGND VPWR VPWR sky130_fd_sc_hd__fill_2
XFILLER_11_204 VGND VGND VPWR VPWR sky130_fd_sc_hd__decap_3
Xclkload2 clkload2/A VGND VGND VPWR VPWR clkload2/Y sky130_fd_sc_hd__inv_6
XTAP_TAPCELL_ROW_44_357 VGND VPWR sky130_fd_sc_hd__tapvpwrvgnd_1
XFILLER_34_318 VGND VGND VPWR VPWR sky130_fd_sc_hd__decap_3
XFILLER_6_296 VGND VGND VPWR VPWR sky130_fd_sc_hd__decap_3
XFILLER_27_3 VGND VGND VPWR VPWR sky130_fd_sc_hd__decap_3
X_1213_ _1705_/A _1324_/A _1321_/A _2020_/Q VGND VGND VPWR VPWR _1255_/B sky130_fd_sc_hd__a2bb2o_2
XFILLER_52_159 VGND VGND VPWR VPWR sky130_fd_sc_hd__fill_2
XFILLER_37_167 VGND VGND VPWR VPWR sky130_fd_sc_hd__fill_1
X_1144_ _1916_/Q _1920_/Q _1924_/Q _1928_/Q _1144_/S0 _1144_/S1 VGND VGND VPWR VPWR
+ _1144_/X sky130_fd_sc_hd__mux4_2
X_1075_ _1229_/A _1229_/B _1222_/A _1054_/X VGND VGND VPWR VPWR _1208_/B sky130_fd_sc_hd__a211o_2
X_1977_ _2077_/CLK _1977_/D VGND VGND VPWR VPWR _1977_/Q sky130_fd_sc_hd__dfxtp_2
X_0928_ _1028_/A VGND VGND VPWR VPWR _1834_/A sky130_fd_sc_hd__inv_2
XFILLER_20_27 VGND VGND VPWR VPWR sky130_fd_sc_hd__fill_1
XFILLER_43_104 VGND VGND VPWR VPWR sky130_fd_sc_hd__decap_3
XTAP_TAPCELL_ROW_41_338 VGND VPWR sky130_fd_sc_hd__tapvpwrvgnd_1
XFILLER_6_29 VGND VGND VPWR VPWR sky130_fd_sc_hd__fill_2
XFILLER_3_288 VGND VGND VPWR VPWR sky130_fd_sc_hd__decap_3
XFILLER_3_266 VGND VGND VPWR VPWR sky130_fd_sc_hd__fill_1
XFILLER_10_93 VGND VGND VPWR VPWR sky130_fd_sc_hd__decap_3
XFILLER_19_134 VGND VGND VPWR VPWR sky130_fd_sc_hd__decap_3
XFILLER_19_178 VGND VGND VPWR VPWR sky130_fd_sc_hd__fill_2
X_1831_ _1418_/A _1831_/B _1831_/C VGND VGND VPWR VPWR _1840_/B sky130_fd_sc_hd__and3b_2
X_1900_ clkload8/A _1900_/D VGND VGND VPWR VPWR _1900_/Q sky130_fd_sc_hd__dfxtp_2
X_1762_ _2047_/Q _1762_/B VGND VGND VPWR VPWR _1762_/X sky130_fd_sc_hd__or2_2
X_1693_ _2015_/Q _1707_/B VGND VGND VPWR VPWR _1693_/X sky130_fd_sc_hd__or2_2
X_1127_ _1985_/Q _1138_/A2 _1138_/B1 _1989_/Q VGND VGND VPWR VPWR _1129_/B sky130_fd_sc_hd__a22o_2
X_1058_ _1227_/A _1227_/B _1227_/C VGND VGND VPWR VPWR _1228_/A sky130_fd_sc_hd__o21a_2
XFILLER_31_37 VGND VGND VPWR VPWR sky130_fd_sc_hd__fill_2
XPHY_EDGE_ROW_1_Right_1 VGND VGND VPWR VPWR sky130_fd_sc_hd__decap_3
XFILLER_0_258 VGND VGND VPWR VPWR sky130_fd_sc_hd__decap_3
XFILLER_16_137 VGND VGND VPWR VPWR sky130_fd_sc_hd__decap_3
XFILLER_12_321 VGND VGND VPWR VPWR sky130_fd_sc_hd__decap_3
X_2030_ _2040_/CLK _2030_/D VGND VGND VPWR VPWR _2030_/Q sky130_fd_sc_hd__dfxtp_2
XFILLER_47_262 VGND VGND VPWR VPWR sky130_fd_sc_hd__fill_1
XFILLER_30_173 VGND VGND VPWR VPWR sky130_fd_sc_hd__decap_3
X_1745_ _1521_/A _1764_/B _1744_/X _1749_/C1 VGND VGND VPWR VPWR _2038_/D sky130_fd_sc_hd__o211a_2
X_1814_ _2074_/Q _2073_/Q VGND VGND VPWR VPWR _1814_/Y sky130_fd_sc_hd__nand2_2
X_1676_ _1676_/A _1683_/B VGND VGND VPWR VPWR _1676_/X sky130_fd_sc_hd__or2_2
XTAP_TAPCELL_ROW_8_155 VGND VPWR sky130_fd_sc_hd__tapvpwrvgnd_1
XFILLER_44_221 VGND VGND VPWR VPWR sky130_fd_sc_hd__fill_1
XFILLER_29_284 VGND VGND VPWR VPWR sky130_fd_sc_hd__decap_3
XFILLER_32_80 VGND VGND VPWR VPWR sky130_fd_sc_hd__decap_3
XFILLER_16_81 VGND VGND VPWR VPWR sky130_fd_sc_hd__decap_3
X_1461_ uo_out[1] _1460_/Y _1458_/Y VGND VGND VPWR VPWR _1913_/D sky130_fd_sc_hd__o21a_2
X_1530_ _1677_/A _1536_/B VGND VGND VPWR VPWR _1530_/Y sky130_fd_sc_hd__nor2_2
X_1392_ _1392_/A _1402_/B VGND VGND VPWR VPWR _1392_/Y sky130_fd_sc_hd__nand2_2
X_2013_ _2068_/CLK _2013_/D VGND VGND VPWR VPWR _2013_/Q sky130_fd_sc_hd__dfxtp_2
Xclkbuf_leaf_15_clk clkbuf_leaf_3_clk/A VGND VGND VPWR VPWR _1897_/CLK sky130_fd_sc_hd__clkbuf_8
Xhold111 _2096_/Q VGND VGND VPWR VPWR _2097_/D sky130_fd_sc_hd__dlygate4sd3_1
X_1728_ hold199/X _2032_/Q _1727_/Y VGND VGND VPWR VPWR _2032_/D sky130_fd_sc_hd__a21oi_2
Xhold133 _1928_/Q VGND VGND VPWR VPWR hold133/X sky130_fd_sc_hd__dlygate4sd3_1
Xhold122 _1995_/Q VGND VGND VPWR VPWR hold122/X sky130_fd_sc_hd__dlygate4sd3_1
Xhold144 _1962_/Q VGND VGND VPWR VPWR hold144/X sky130_fd_sc_hd__dlygate4sd3_1
Xhold155 _1999_/Q VGND VGND VPWR VPWR hold155/X sky130_fd_sc_hd__dlygate4sd3_1
Xhold199 _2031_/Q VGND VGND VPWR VPWR hold199/X sky130_fd_sc_hd__dlygate4sd3_1
X_1659_ hold155/X _1626_/B _1659_/S VGND VGND VPWR VPWR _1999_/D sky130_fd_sc_hd__mux2_1
Xhold177 _1997_/Q VGND VGND VPWR VPWR hold177/X sky130_fd_sc_hd__dlygate4sd3_1
Xhold188 _2004_/Q VGND VGND VPWR VPWR hold188/X sky130_fd_sc_hd__dlygate4sd3_1
Xhold166 _1954_/Q VGND VGND VPWR VPWR hold166/X sky130_fd_sc_hd__dlygate4sd3_1
XFILLER_37_69 VGND VGND VPWR VPWR sky130_fd_sc_hd__decap_3
XFILLER_26_232 VGND VGND VPWR VPWR sky130_fd_sc_hd__decap_3
XTAP_TAPCELL_ROW_19_216 VGND VPWR sky130_fd_sc_hd__tapvpwrvgnd_1
XFILLER_32_213 VGND VGND VPWR VPWR sky130_fd_sc_hd__decap_3
XTAP_TAPCELL_ROW_27_260 VGND VPWR sky130_fd_sc_hd__tapvpwrvgnd_1
X_0961_ _2090_/Q _2091_/Q _0961_/C VGND VGND VPWR VPWR _0964_/B sky130_fd_sc_hd__and3_2
XTAP_TAPCELL_ROW_10_171 VGND VPWR sky130_fd_sc_hd__tapvpwrvgnd_1
X_1444_ _2134_/A _1443_/B _1907_/Q VGND VGND VPWR VPWR _1444_/Y sky130_fd_sc_hd__a21oi_2
X_1375_ _1400_/A _1381_/B VGND VGND VPWR VPWR _1375_/Y sky130_fd_sc_hd__nand2_2
Xclkbuf_leaf_4_clk clkbuf_leaf_9_clk/A VGND VGND VPWR VPWR _1963_/CLK sky130_fd_sc_hd__clkbuf_8
X_1513_ _1518_/A1 _1497_/A _1510_/X _1509_/X VGND VGND VPWR VPWR _1922_/D sky130_fd_sc_hd__a31o_2
XFILLER_4_73 VGND VGND VPWR VPWR sky130_fd_sc_hd__decap_3
XTAP_TAPCELL_ROW_33_296 VGND VPWR sky130_fd_sc_hd__tapvpwrvgnd_1
XFILLER_31_290 VGND VGND VPWR VPWR sky130_fd_sc_hd__fill_1
XFILLER_23_279 VGND VGND VPWR VPWR sky130_fd_sc_hd__fill_1
XFILLER_23_268 VGND VGND VPWR VPWR sky130_fd_sc_hd__decap_3
XFILLER_14_235 VGND VGND VPWR VPWR sky130_fd_sc_hd__fill_1
XFILLER_14_268 VGND VGND VPWR VPWR sky130_fd_sc_hd__decap_3
Xfanout83 input2/X VGND VGND VPWR VPWR _1736_/B sky130_fd_sc_hd__clkdlybuf4s25_1
Xfanout72 _1909_/Q VGND VGND VPWR VPWR _1143_/S0 sky130_fd_sc_hd__clkdlybuf4s25_1
Xfanout50 _0919_/Y VGND VGND VPWR VPWR _1816_/A sky130_fd_sc_hd__clkdlybuf4s25_1
Xfanout94 input1/X VGND VGND VPWR VPWR fanout94/X sky130_fd_sc_hd__clkdlybuf4s25_1
Xfanout61 _2050_/Q VGND VGND VPWR VPWR _1506_/A sky130_fd_sc_hd__clkdlybuf4s25_1
X_1091_ _1951_/Q _1955_/Q _1959_/Q _1963_/Q _1113_/S0 _1141_/S1 VGND VGND VPWR VPWR
+ _1091_/X sky130_fd_sc_hd__mux4_2
X_1160_ _1222_/A _1160_/B VGND VGND VPWR VPWR _1218_/A sky130_fd_sc_hd__xor2_2
X_1993_ _2001_/CLK _1993_/D VGND VGND VPWR VPWR _1993_/Q sky130_fd_sc_hd__dfxtp_2
X_0944_ _2082_/Q _0943_/C _2083_/Q VGND VGND VPWR VPWR _0945_/B sky130_fd_sc_hd__a21oi_2
XTAP_TAPCELL_ROW_30_277 VGND VPWR sky130_fd_sc_hd__tapvpwrvgnd_1
X_1427_ _1427_/A VGND VGND VPWR VPWR _1427_/Y sky130_fd_sc_hd__inv_2
X_1358_ _1383_/A _1462_/A VGND VGND VPWR VPWR _1358_/Y sky130_fd_sc_hd__nor2_2
XTAP_TAPCELL_ROW_38_322 VGND VPWR sky130_fd_sc_hd__tapvpwrvgnd_1
X_1289_ _1252_/X _1288_/X _1290_/A _1254_/B VGND VGND VPWR VPWR _1289_/X sky130_fd_sc_hd__a211o_2
Xclkload3 clkload3/A VGND VGND VPWR VPWR clkload3/X sky130_fd_sc_hd__clkbuf_4
XFILLER_7_209 VGND VGND VPWR VPWR sky130_fd_sc_hd__decap_3
XFILLER_11_216 VGND VGND VPWR VPWR sky130_fd_sc_hd__decap_3
XTAP_TAPCELL_ROW_44_358 VGND VPWR sky130_fd_sc_hd__tapvpwrvgnd_1
XFILLER_6_253 VGND VGND VPWR VPWR sky130_fd_sc_hd__decap_3
XFILLER_10_271 VGND VGND VPWR VPWR sky130_fd_sc_hd__decap_3
X_1212_ _1212_/A _1212_/B VGND VGND VPWR VPWR _1321_/A sky130_fd_sc_hd__or2_2
X_1143_ _1932_/Q _1936_/Q _1940_/Q _1944_/Q _1143_/S0 _1144_/S1 VGND VGND VPWR VPWR
+ _1143_/X sky130_fd_sc_hd__mux4_2
X_1074_ _1229_/A _1229_/B VGND VGND VPWR VPWR _1230_/A sky130_fd_sc_hd__and2_2
X_0927_ _2016_/Q VGND VGND VPWR VPWR _1695_/A sky130_fd_sc_hd__inv_2
X_1976_ _2064_/CLK _1976_/D VGND VGND VPWR VPWR _1976_/Q sky130_fd_sc_hd__dfxtp_2
XFILLER_16_319 VGND VGND VPWR VPWR sky130_fd_sc_hd__decap_3
XTAP_TAPCELL_ROW_41_339 VGND VPWR sky130_fd_sc_hd__tapvpwrvgnd_1
XFILLER_19_113 VGND VGND VPWR VPWR sky130_fd_sc_hd__decap_3
XFILLER_19_92 VGND VGND VPWR VPWR sky130_fd_sc_hd__decap_3
XFILLER_19_146 VGND VGND VPWR VPWR sky130_fd_sc_hd__fill_2
X_1830_ _1903_/Q _1902_/Q _1830_/C _1830_/D VGND VGND VPWR VPWR _1836_/S sky130_fd_sc_hd__or4_2
XFILLER_35_80 VGND VGND VPWR VPWR sky130_fd_sc_hd__fill_2
X_1761_ _2058_/Q _1764_/B _1760_/X _1789_/B1 VGND VGND VPWR VPWR _2046_/D sky130_fd_sc_hd__o211a_2
X_1692_ _1770_/B _1697_/B _1691_/X _1779_/B1 VGND VGND VPWR VPWR _2014_/D sky130_fd_sc_hd__o211a_2
X_1126_ _1147_/A _1126_/B VGND VGND VPWR VPWR _1149_/B sky130_fd_sc_hd__and2_2
X_1057_ _1227_/C VGND VGND VPWR VPWR _1229_/A sky130_fd_sc_hd__inv_2
X_1959_ _1963_/CLK _1959_/D VGND VGND VPWR VPWR _1959_/Q sky130_fd_sc_hd__dfxtp_2
XFILLER_0_248 VGND VGND VPWR VPWR sky130_fd_sc_hd__decap_3
XFILLER_16_127 VGND VGND VPWR VPWR sky130_fd_sc_hd__fill_2
XFILLER_24_171 VGND VGND VPWR VPWR sky130_fd_sc_hd__fill_1
XFILLER_8_304 VGND VGND VPWR VPWR sky130_fd_sc_hd__decap_3
XFILLER_12_300 VGND VGND VPWR VPWR sky130_fd_sc_hd__decap_3
Xclkbuf_0_clk clk VGND VGND VPWR VPWR clkbuf_0_clk/X sky130_fd_sc_hd__clkbuf_16
X_1744_ _2038_/Q _1754_/B VGND VGND VPWR VPWR _1744_/X sky130_fd_sc_hd__or2_2
XFILLER_7_51 VGND VGND VPWR VPWR sky130_fd_sc_hd__decap_3
X_1813_ _2071_/Q _1816_/A _1824_/A _1812_/X VGND VGND VPWR VPWR _2072_/D sky130_fd_sc_hd__o211a_2
XPHY_EDGE_ROW_15_Left_68 VGND VGND VPWR VPWR sky130_fd_sc_hd__decap_3
X_1675_ _1675_/A _1675_/B VGND VGND VPWR VPWR _1683_/B sky130_fd_sc_hd__or2_2
XPHY_EDGE_ROW_15_Right_15 VGND VGND VPWR VPWR sky130_fd_sc_hd__decap_3
X_1109_ _1934_/Q _1938_/Q _1942_/Q _1946_/Q _1143_/S0 _1144_/S1 VGND VGND VPWR VPWR
+ _1109_/X sky130_fd_sc_hd__mux4_2
XFILLER_26_38 VGND VGND VPWR VPWR sky130_fd_sc_hd__fill_2
XPHY_EDGE_ROW_24_Right_24 VGND VGND VPWR VPWR sky130_fd_sc_hd__decap_3
X_2089_ fanout93/X _2089_/D osc_en VGND VGND VPWR VPWR _2089_/Q sky130_fd_sc_hd__dfrtp_2
XFILLER_42_37 VGND VGND VPWR VPWR sky130_fd_sc_hd__decap_3
XFILLER_13_119 VGND VGND VPWR VPWR sky130_fd_sc_hd__decap_3
XPHY_EDGE_ROW_33_Right_33 VGND VGND VPWR VPWR sky130_fd_sc_hd__decap_3
XTAP_TAPCELL_ROW_8_156 VGND VPWR sky130_fd_sc_hd__tapvpwrvgnd_1
XFILLER_44_299 VGND VGND VPWR VPWR sky130_fd_sc_hd__fill_2
XFILLER_44_266 VGND VGND VPWR VPWR sky130_fd_sc_hd__fill_2
XFILLER_44_200 VGND VGND VPWR VPWR sky130_fd_sc_hd__decap_3
XPHY_EDGE_ROW_42_Right_42 VGND VGND VPWR VPWR sky130_fd_sc_hd__decap_3
XPHY_EDGE_ROW_51_Right_51 VGND VGND VPWR VPWR sky130_fd_sc_hd__decap_3
X_1460_ _1460_/A _1464_/B VGND VGND VPWR VPWR _1460_/Y sky130_fd_sc_hd__nor2_2
X_1391_ _1891_/Q _1390_/B _1390_/Y _1723_/C1 VGND VGND VPWR VPWR _1891_/D sky130_fd_sc_hd__o211a_2
X_2012_ _2068_/CLK _2012_/D VGND VGND VPWR VPWR _2012_/Q sky130_fd_sc_hd__dfxtp_2
XFILLER_35_277 VGND VGND VPWR VPWR sky130_fd_sc_hd__decap_3
X_1727_ _2031_/Q _2032_/Q _1736_/B VGND VGND VPWR VPWR _1727_/Y sky130_fd_sc_hd__o21ai_2
Xhold167 _2034_/Q VGND VGND VPWR VPWR hold167/X sky130_fd_sc_hd__dlygate4sd3_1
Xhold112 _2101_/Q VGND VGND VPWR VPWR _2102_/D sky130_fd_sc_hd__dlygate4sd3_1
Xhold145 _2008_/Q VGND VGND VPWR VPWR hold145/X sky130_fd_sc_hd__dlygate4sd3_1
X_1658_ hold150/X _1624_/B _1659_/S VGND VGND VPWR VPWR _1998_/D sky130_fd_sc_hd__mux2_1
Xhold123 _1938_/Q VGND VGND VPWR VPWR hold123/X sky130_fd_sc_hd__dlygate4sd3_1
Xhold134 _1991_/Q VGND VGND VPWR VPWR hold134/X sky130_fd_sc_hd__dlygate4sd3_1
Xhold156 _1973_/Q VGND VGND VPWR VPWR hold156/X sky130_fd_sc_hd__dlygate4sd3_1
Xhold178 _1930_/Q VGND VGND VPWR VPWR hold178/X sky130_fd_sc_hd__dlygate4sd3_1
X_1589_ hold168/X _1620_/B _1592_/S VGND VGND VPWR VPWR _1956_/D sky130_fd_sc_hd__mux2_1
Xhold189 _1964_/Q VGND VGND VPWR VPWR hold189/X sky130_fd_sc_hd__dlygate4sd3_1
XFILLER_41_225 VGND VGND VPWR VPWR sky130_fd_sc_hd__decap_3
XFILLER_26_277 VGND VGND VPWR VPWR sky130_fd_sc_hd__decap_3
XTAP_TAPCELL_ROW_19_217 VGND VPWR sky130_fd_sc_hd__tapvpwrvgnd_1
XFILLER_40_280 VGND VGND VPWR VPWR sky130_fd_sc_hd__decap_3
XFILLER_32_203 VGND VGND VPWR VPWR sky130_fd_sc_hd__decap_3
XTAP_TAPCELL_ROW_27_261 VGND VPWR sky130_fd_sc_hd__tapvpwrvgnd_1
X_0960_ _2090_/Q _0961_/C VGND VGND VPWR VPWR _2090_/D sky130_fd_sc_hd__xor2_2
X_1512_ _1770_/B _1521_/B VGND VGND VPWR VPWR _1624_/B sky130_fd_sc_hd__and2_2
X_1443_ _2134_/A _1443_/B VGND VGND VPWR VPWR _1443_/Y sky130_fd_sc_hd__nand2_2
X_1374_ _1883_/Q _1377_/B _1373_/Y _1395_/C1 VGND VGND VPWR VPWR _1883_/D sky130_fd_sc_hd__o211a_2
XFILLER_4_41 VGND VGND VPWR VPWR sky130_fd_sc_hd__decap_3
XFILLER_23_247 VGND VGND VPWR VPWR sky130_fd_sc_hd__decap_3
XFILLER_23_225 VGND VGND VPWR VPWR sky130_fd_sc_hd__decap_3
XTAP_TAPCELL_ROW_33_297 VGND VPWR sky130_fd_sc_hd__tapvpwrvgnd_1
XFILLER_3_9 VGND VGND VPWR VPWR sky130_fd_sc_hd__decap_3
XPHY_EDGE_ROW_18_Left_71 VGND VGND VPWR VPWR sky130_fd_sc_hd__decap_3
Xfanout40 _1003_/X VGND VGND VPWR VPWR _1138_/B1 sky130_fd_sc_hd__clkdlybuf4s25_1
Xfanout62 _2049_/Q VGND VGND VPWR VPWR _1521_/A sky130_fd_sc_hd__clkdlybuf4s25_1
XFILLER_14_203 VGND VGND VPWR VPWR sky130_fd_sc_hd__decap_3
Xfanout51 _2095_/Q VGND VGND VPWR VPWR _1808_/A sky130_fd_sc_hd__clkdlybuf4s25_1
Xfanout84 _1723_/C1 VGND VGND VPWR VPWR _1749_/C1 sky130_fd_sc_hd__clkdlybuf4s25_1
X_1090_ _1967_/Q _1971_/Q _1975_/Q _1979_/Q _1113_/S0 _1141_/S1 VGND VGND VPWR VPWR
+ _1090_/X sky130_fd_sc_hd__mux4_2
X_1992_ _2001_/CLK _1992_/D VGND VGND VPWR VPWR _1992_/Q sky130_fd_sc_hd__dfxtp_2
XTAP_TAPCELL_ROW_30_278 VGND VPWR sky130_fd_sc_hd__tapvpwrvgnd_1
X_0943_ _2082_/Q _2083_/Q _0943_/C VGND VGND VPWR VPWR _0947_/B sky130_fd_sc_hd__and3_2
XFILLER_9_284 VGND VGND VPWR VPWR sky130_fd_sc_hd__decap_3
XFILLER_20_228 VGND VGND VPWR VPWR sky130_fd_sc_hd__decap_3
X_1426_ _1431_/B _1426_/B VGND VGND VPWR VPWR _1427_/A sky130_fd_sc_hd__nor2_2
XTAP_TAPCELL_ROW_38_323 VGND VPWR sky130_fd_sc_hd__tapvpwrvgnd_1
X_1357_ _1383_/A _1460_/A _1187_/Y _1356_/X _1846_/C VGND VGND VPWR VPWR _1875_/D
+ sky130_fd_sc_hd__o311a_2
X_1288_ _1697_/A _1312_/A _1309_/A _1695_/A VGND VGND VPWR VPWR _1288_/X sky130_fd_sc_hd__a211o_2
XFILLER_11_228 VGND VGND VPWR VPWR sky130_fd_sc_hd__fill_2
Xclkload4 clkload4/A VGND VGND VPWR VPWR clkload4/X sky130_fd_sc_hd__clkbuf_4
XPHY_EDGE_ROW_3_Left_56 VGND VGND VPWR VPWR sky130_fd_sc_hd__decap_3
XFILLER_1_6 VGND VGND VPWR VPWR sky130_fd_sc_hd__decap_3
XFILLER_46_158 VGND VGND VPWR VPWR sky130_fd_sc_hd__decap_3
XFILLER_42_320 VGND VGND VPWR VPWR sky130_fd_sc_hd__fill_1
XFILLER_24_93 VGND VGND VPWR VPWR sky130_fd_sc_hd__fill_1
XFILLER_6_232 VGND VGND VPWR VPWR sky130_fd_sc_hd__decap_3
XFILLER_6_276 VGND VGND VPWR VPWR sky130_fd_sc_hd__decap_3
XFILLER_10_283 VGND VGND VPWR VPWR sky130_fd_sc_hd__decap_3
X_1142_ _1141_/X _1140_/X _1145_/S VGND VGND VPWR VPWR _1142_/X sky130_fd_sc_hd__mux2_1
X_1211_ _1211_/A1 _1201_/B _1210_/X _1209_/X _1266_/B1 VGND VGND VPWR VPWR _1212_/B
+ sky130_fd_sc_hd__o311a_2
XFILLER_37_169 VGND VGND VPWR VPWR sky130_fd_sc_hd__fill_1
XTAP_TAPCELL_ROW_35_304 VGND VPWR sky130_fd_sc_hd__tapvpwrvgnd_1
X_1073_ _1245_/C _1244_/B _1050_/X VGND VGND VPWR VPWR _1229_/B sky130_fd_sc_hd__a21o_2
X_0926_ _2017_/Q VGND VGND VPWR VPWR _1697_/A sky130_fd_sc_hd__inv_2
X_1975_ _2077_/CLK _1975_/D VGND VGND VPWR VPWR _1975_/Q sky130_fd_sc_hd__dfxtp_2
XPHY_EDGE_ROW_45_Left_98 VGND VGND VPWR VPWR sky130_fd_sc_hd__decap_3
X_1409_ _1900_/Q _1409_/B _1441_/B VGND VGND VPWR VPWR _1850_/A sky130_fd_sc_hd__and3_2
XFILLER_29_38 VGND VGND VPWR VPWR sky130_fd_sc_hd__fill_1
XFILLER_28_136 VGND VGND VPWR VPWR sky130_fd_sc_hd__decap_3
XFILLER_28_125 VGND VGND VPWR VPWR sky130_fd_sc_hd__decap_3
XFILLER_24_320 VGND VGND VPWR VPWR sky130_fd_sc_hd__decap_3
XFILLER_3_246 VGND VGND VPWR VPWR sky130_fd_sc_hd__decap_3
XFILLER_19_125 VGND VGND VPWR VPWR sky130_fd_sc_hd__fill_1
XFILLER_19_169 VGND VGND VPWR VPWR sky130_fd_sc_hd__decap_3
XFILLER_30_323 VGND VGND VPWR VPWR sky130_fd_sc_hd__fill_1
X_1760_ _2046_/Q _1760_/B VGND VGND VPWR VPWR _1760_/X sky130_fd_sc_hd__or2_2
X_1691_ _2014_/Q _1707_/B VGND VGND VPWR VPWR _1691_/X sky130_fd_sc_hd__or2_2
X_1125_ _1124_/X _1121_/X _1146_/S VGND VGND VPWR VPWR _1126_/B sky130_fd_sc_hd__mux2_1
XFILLER_33_161 VGND VGND VPWR VPWR sky130_fd_sc_hd__fill_1
X_1056_ _1222_/B _1056_/B VGND VGND VPWR VPWR _1227_/C sky130_fd_sc_hd__nor2_2
XFILLER_21_323 VGND VGND VPWR VPWR sky130_fd_sc_hd__fill_1
X_1958_ clkload0/A _1958_/D VGND VGND VPWR VPWR _1958_/Q sky130_fd_sc_hd__dfxtp_2
X_1889_ clkload6/A _1889_/D VGND VGND VPWR VPWR _1889_/Q sky130_fd_sc_hd__dfxtp_2
XFILLER_30_131 VGND VGND VPWR VPWR sky130_fd_sc_hd__fill_1
XFILLER_15_150 VGND VGND VPWR VPWR sky130_fd_sc_hd__fill_1
XFILLER_15_183 VGND VGND VPWR VPWR sky130_fd_sc_hd__decap_3
X_1674_ hold151/X _1626_/B _1674_/S VGND VGND VPWR VPWR _2007_/D sky130_fd_sc_hd__mux2_1
XFILLER_30_197 VGND VGND VPWR VPWR sky130_fd_sc_hd__fill_2
X_1812_ _2072_/Q _2093_/D VGND VGND VPWR VPWR _1812_/X sky130_fd_sc_hd__or2_2
X_1743_ _2070_/Q _2069_/Q _1743_/C _2071_/Q VGND VGND VPWR VPWR _1743_/X sky130_fd_sc_hd__or4b_2
X_1108_ _1082_/Y _1105_/X _1107_/X _1087_/Y VGND VGND VPWR VPWR _1152_/B sky130_fd_sc_hd__o211a_2
X_2088_ fanout93/X _2088_/D osc_en VGND VGND VPWR VPWR _2088_/Q sky130_fd_sc_hd__dfrtp_2
X_1039_ _1258_/A _1258_/B VGND VGND VPWR VPWR _1039_/X sky130_fd_sc_hd__and2_2
XFILLER_21_153 VGND VGND VPWR VPWR sky130_fd_sc_hd__decap_3
XTAP_TAPCELL_ROW_8_157 VGND VPWR sky130_fd_sc_hd__tapvpwrvgnd_1
XFILLER_29_264 VGND VGND VPWR VPWR sky130_fd_sc_hd__decap_3
XFILLER_29_242 VGND VGND VPWR VPWR sky130_fd_sc_hd__decap_3
XFILLER_29_220 VGND VGND VPWR VPWR sky130_fd_sc_hd__decap_3
XPHY_EDGE_ROW_32_Left_85 VGND VGND VPWR VPWR sky130_fd_sc_hd__decap_3
XFILLER_12_131 VGND VGND VPWR VPWR sky130_fd_sc_hd__decap_3
X_1390_ _1390_/A _1390_/B VGND VGND VPWR VPWR _1390_/Y sky130_fd_sc_hd__nand2_2
X_2011_ _2036_/CLK _2011_/D VGND VGND VPWR VPWR _2011_/Q sky130_fd_sc_hd__dfxtp_2
XFILLER_35_289 VGND VGND VPWR VPWR sky130_fd_sc_hd__decap_3
XFILLER_35_256 VGND VGND VPWR VPWR sky130_fd_sc_hd__fill_2
XFILLER_35_223 VGND VGND VPWR VPWR sky130_fd_sc_hd__fill_1
Xhold113 _2094_/Q VGND VGND VPWR VPWR _2095_/D sky130_fd_sc_hd__dlygate4sd3_1
X_1726_ _2031_/Q _1830_/C VGND VGND VPWR VPWR _2031_/D sky130_fd_sc_hd__nor2_2
Xhold135 _2114_/Q VGND VGND VPWR VPWR hold135/X sky130_fd_sc_hd__dlygate4sd3_1
Xhold124 _1939_/Q VGND VGND VPWR VPWR hold124/X sky130_fd_sc_hd__dlygate4sd3_1
X_1657_ hold177/X _1622_/B _1659_/S VGND VGND VPWR VPWR _1997_/D sky130_fd_sc_hd__mux2_1
Xhold146 _2009_/Q VGND VGND VPWR VPWR hold146/X sky130_fd_sc_hd__dlygate4sd3_1
Xhold157 _1931_/Q VGND VGND VPWR VPWR hold157/X sky130_fd_sc_hd__dlygate4sd3_1
X_1588_ _1588_/A _1604_/B VGND VGND VPWR VPWR _1592_/S sky130_fd_sc_hd__nor2_2
Xhold179 _1955_/Q VGND VGND VPWR VPWR hold179/X sky130_fd_sc_hd__dlygate4sd3_1
Xhold168 _1956_/Q VGND VGND VPWR VPWR hold168/X sky130_fd_sc_hd__dlygate4sd3_1
XFILLER_37_38 VGND VGND VPWR VPWR sky130_fd_sc_hd__fill_1
XFILLER_41_237 VGND VGND VPWR VPWR sky130_fd_sc_hd__fill_1
XFILLER_1_322 VGND VGND VPWR VPWR sky130_fd_sc_hd__fill_2
XFILLER_17_278 VGND VGND VPWR VPWR sky130_fd_sc_hd__fill_2
XTAP_TAPCELL_ROW_19_218 VGND VPWR sky130_fd_sc_hd__tapvpwrvgnd_1
Xclkbuf_2_0__f_clk clkbuf_0_clk/X VGND VGND VPWR VPWR clkbuf_leaf_2_clk/A sky130_fd_sc_hd__clkbuf_16
XFILLER_43_92 VGND VGND VPWR VPWR sky130_fd_sc_hd__fill_2
XFILLER_40_270 VGND VGND VPWR VPWR sky130_fd_sc_hd__fill_2
XTAP_TAPCELL_ROW_27_262 VGND VPWR sky130_fd_sc_hd__tapvpwrvgnd_1
XFILLER_17_289 VGND VGND VPWR VPWR sky130_fd_sc_hd__decap_3
X_1442_ _1443_/B VGND VGND VPWR VPWR _1442_/Y sky130_fd_sc_hd__inv_2
X_1511_ _1770_/B _1598_/A VGND VGND VPWR VPWR _1681_/A sky130_fd_sc_hd__nand2_2
X_1373_ _1398_/A _1377_/B VGND VGND VPWR VPWR _1373_/Y sky130_fd_sc_hd__nand2_2
XFILLER_23_259 VGND VGND VPWR VPWR sky130_fd_sc_hd__decap_3
X_1709_ _1709_/A _1709_/B VGND VGND VPWR VPWR _1709_/Y sky130_fd_sc_hd__nand2_2
Xfanout41 _1003_/X VGND VGND VPWR VPWR _1337_/A1 sky130_fd_sc_hd__clkdlybuf4s25_1
Xfanout74 _1832_/A0 VGND VGND VPWR VPWR _1449_/A sky130_fd_sc_hd__clkdlybuf4s25_1
Xfanout30 _1356_/B VGND VGND VPWR VPWR _1342_/B sky130_fd_sc_hd__clkdlybuf4s25_1
Xfanout52 _2093_/D VGND VGND VPWR VPWR _1806_/A sky130_fd_sc_hd__clkdlybuf4s25_1
XTAP_TAPCELL_ROW_24_243 VGND VPWR sky130_fd_sc_hd__tapvpwrvgnd_1
Xfanout85 _1837_/C VGND VGND VPWR VPWR _1723_/C1 sky130_fd_sc_hd__clkdlybuf4s25_1
Xfanout63 _1756_/A VGND VGND VPWR VPWR osc_en sky130_fd_sc_hd__clkdlybuf4s25_1
XFILLER_14_259 VGND VGND VPWR VPWR sky130_fd_sc_hd__decap_3
XFILLER_22_270 VGND VGND VPWR VPWR sky130_fd_sc_hd__decap_3
XFILLER_49_189 VGND VGND VPWR VPWR sky130_fd_sc_hd__decap_3
XFILLER_49_167 VGND VGND VPWR VPWR sky130_fd_sc_hd__fill_1
XFILLER_49_101 VGND VGND VPWR VPWR sky130_fd_sc_hd__fill_2
X_1991_ _2001_/CLK _1991_/D VGND VGND VPWR VPWR _1991_/Q sky130_fd_sc_hd__dfxtp_2
XTAP_TAPCELL_ROW_30_279 VGND VPWR sky130_fd_sc_hd__tapvpwrvgnd_1
X_0942_ _2082_/Q _0943_/C VGND VGND VPWR VPWR _2082_/D sky130_fd_sc_hd__xor2_2
XFILLER_9_230 VGND VGND VPWR VPWR sky130_fd_sc_hd__decap_3
XFILLER_9_296 VGND VGND VPWR VPWR sky130_fd_sc_hd__decap_3
XFILLER_13_281 VGND VGND VPWR VPWR sky130_fd_sc_hd__fill_1
X_1425_ _1424_/B _1904_/Q VGND VGND VPWR VPWR _1426_/B sky130_fd_sc_hd__and2b_2
X_1356_ _1875_/Q _1356_/B VGND VGND VPWR VPWR _1356_/X sky130_fd_sc_hd__or2_2
XTAP_TAPCELL_ROW_38_324 VGND VPWR sky130_fd_sc_hd__tapvpwrvgnd_1
XFILLER_28_318 VGND VGND VPWR VPWR sky130_fd_sc_hd__decap_3
XFILLER_28_307 VGND VGND VPWR VPWR sky130_fd_sc_hd__fill_1
X_1287_ _1204_/Y _1255_/B _1188_/Y _1196_/X VGND VGND VPWR VPWR _1287_/Y sky130_fd_sc_hd__a211oi_2
Xclkload5 clkload5/A VGND VGND VPWR VPWR clkload5/Y sky130_fd_sc_hd__clkinv_2
XFILLER_11_207 VGND VGND VPWR VPWR sky130_fd_sc_hd__decap_3
XFILLER_6_200 VGND VGND VPWR VPWR sky130_fd_sc_hd__decap_3
XFILLER_6_222 VGND VGND VPWR VPWR sky130_fd_sc_hd__decap_3
XFILLER_10_251 VGND VGND VPWR VPWR sky130_fd_sc_hd__fill_1
XFILLER_10_262 VGND VGND VPWR VPWR sky130_fd_sc_hd__fill_1
XFILLER_40_93 VGND VGND VPWR VPWR sky130_fd_sc_hd__decap_3
XFILLER_6_266 VGND VGND VPWR VPWR sky130_fd_sc_hd__fill_1
XFILLER_6_299 VGND VGND VPWR VPWR sky130_fd_sc_hd__fill_1
XFILLER_27_6 VGND VGND VPWR VPWR sky130_fd_sc_hd__fill_2
X_1141_ _1948_/Q _1952_/Q _1956_/Q _1960_/Q _1141_/S0 _1141_/S1 VGND VGND VPWR VPWR
+ _1141_/X sky130_fd_sc_hd__mux4_2
X_1072_ _1236_/C _1235_/B _1046_/X VGND VGND VPWR VPWR _1244_/B sky130_fd_sc_hd__a21o_2
X_1210_ _1208_/A _1210_/B VGND VGND VPWR VPWR _1210_/X sky130_fd_sc_hd__and2b_2
XTAP_TAPCELL_ROW_35_305 VGND VPWR sky130_fd_sc_hd__tapvpwrvgnd_1
X_1974_ clkload0/A _1974_/D VGND VGND VPWR VPWR _1974_/Q sky130_fd_sc_hd__dfxtp_2
X_0925_ _2021_/Q VGND VGND VPWR VPWR _1705_/A sky130_fd_sc_hd__inv_2
X_1408_ _1409_/B _1441_/B VGND VGND VPWR VPWR _1424_/B sky130_fd_sc_hd__and2_2
XFILLER_43_107 VGND VGND VPWR VPWR sky130_fd_sc_hd__decap_3
X_1339_ _1866_/Q _1342_/B _1338_/Y _1389_/C1 VGND VGND VPWR VPWR _1866_/D sky130_fd_sc_hd__o211a_2
XFILLER_3_225 VGND VGND VPWR VPWR sky130_fd_sc_hd__decap_3
XFILLER_3_203 VGND VGND VPWR VPWR sky130_fd_sc_hd__decap_3
XFILLER_10_96 VGND VGND VPWR VPWR sky130_fd_sc_hd__fill_2
XFILLER_19_137 VGND VGND VPWR VPWR sky130_fd_sc_hd__decap_3
XFILLER_35_60 VGND VGND VPWR VPWR sky130_fd_sc_hd__decap_3
XFILLER_30_302 VGND VGND VPWR VPWR sky130_fd_sc_hd__fill_1
X_1690_ _1506_/A _1697_/B _1689_/X _1723_/C1 VGND VGND VPWR VPWR _2013_/D sky130_fd_sc_hd__o211a_2
XFILLER_25_3 VGND VGND VPWR VPWR sky130_fd_sc_hd__decap_3
X_1124_ _1123_/X _1122_/X _1145_/S VGND VGND VPWR VPWR _1124_/X sky130_fd_sc_hd__mux2_1
X_1055_ _2030_/Q _1159_/A VGND VGND VPWR VPWR _1056_/B sky130_fd_sc_hd__nor2_2
XFILLER_18_192 VGND VGND VPWR VPWR sky130_fd_sc_hd__decap_3
XFILLER_33_140 VGND VGND VPWR VPWR sky130_fd_sc_hd__decap_3
X_1957_ clkload0/A _1957_/D VGND VGND VPWR VPWR _1957_/Q sky130_fd_sc_hd__dfxtp_2
X_1888_ clkload5/A _1888_/D VGND VGND VPWR VPWR _1888_/Q sky130_fd_sc_hd__dfxtp_2
XFILLER_0_239 VGND VGND VPWR VPWR sky130_fd_sc_hd__decap_3
XFILLER_24_184 VGND VGND VPWR VPWR sky130_fd_sc_hd__decap_3
XFILLER_16_118 VGND VGND VPWR VPWR sky130_fd_sc_hd__decap_3
XFILLER_30_176 VGND VGND VPWR VPWR sky130_fd_sc_hd__fill_2
XFILLER_30_110 VGND VGND VPWR VPWR sky130_fd_sc_hd__decap_3
X_1811_ _1816_/A _2070_/Q _1811_/B1 _1810_/X VGND VGND VPWR VPWR _2071_/D sky130_fd_sc_hd__o211a_2
X_1673_ hold162/X _1624_/B _1674_/S VGND VGND VPWR VPWR _2006_/D sky130_fd_sc_hd__mux2_1
XFILLER_7_75 VGND VGND VPWR VPWR sky130_fd_sc_hd__fill_2
X_1742_ _2070_/Q _2069_/Q _1743_/C _2071_/Q VGND VGND VPWR VPWR _1762_/B sky130_fd_sc_hd__nor4b_2
X_1107_ _1982_/Q _1137_/A2 _1441_/B _1994_/Q _1106_/X VGND VGND VPWR VPWR _1107_/X
+ sky130_fd_sc_hd__a221o_2
Xclkbuf_leaf_18_clk clkbuf_2_2__f_clk/X VGND VGND VPWR VPWR clkload7/A sky130_fd_sc_hd__clkbuf_8
X_2087_ fanout93/X _2087_/D osc_en VGND VGND VPWR VPWR _2087_/Q sky130_fd_sc_hd__dfrtp_2
XPHY_EDGE_ROW_5_Right_5 VGND VGND VPWR VPWR sky130_fd_sc_hd__decap_3
X_1038_ _1038_/A _1152_/A VGND VGND VPWR VPWR _1258_/B sky130_fd_sc_hd__xnor2_2
XFILLER_21_121 VGND VGND VPWR VPWR sky130_fd_sc_hd__decap_3
XFILLER_21_165 VGND VGND VPWR VPWR sky130_fd_sc_hd__decap_3
XTAP_TAPCELL_ROW_8_158 VGND VPWR sky130_fd_sc_hd__tapvpwrvgnd_1
XFILLER_29_287 VGND VGND VPWR VPWR sky130_fd_sc_hd__decap_3
XFILLER_29_254 VGND VGND VPWR VPWR sky130_fd_sc_hd__fill_2
XFILLER_12_110 VGND VGND VPWR VPWR sky130_fd_sc_hd__decap_3
XFILLER_12_176 VGND VGND VPWR VPWR sky130_fd_sc_hd__decap_3
XFILLER_32_83 VGND VGND VPWR VPWR sky130_fd_sc_hd__fill_1
X_2010_ clkload4/A _2010_/D VGND VGND VPWR VPWR _2010_/Q sky130_fd_sc_hd__dfxtp_2
X_1725_ _2030_/Q _1724_/B _1724_/Y _1749_/C1 VGND VGND VPWR VPWR _2030_/D sky130_fd_sc_hd__o211a_2
Xhold169 _1935_/Q VGND VGND VPWR VPWR hold169/X sky130_fd_sc_hd__dlygate4sd3_1
Xhold114 _2099_/Q VGND VGND VPWR VPWR _2100_/D sky130_fd_sc_hd__dlygate4sd3_1
Xhold125 _2110_/Q VGND VGND VPWR VPWR hold125/X sky130_fd_sc_hd__dlygate4sd3_1
Xclkbuf_leaf_7_clk clkbuf_leaf_9_clk/A VGND VGND VPWR VPWR _2036_/CLK sky130_fd_sc_hd__clkbuf_8
X_1656_ hold187/X _1620_/B _1659_/S VGND VGND VPWR VPWR _1996_/D sky130_fd_sc_hd__mux2_1
X_1587_ hold179/X _2052_/Q _1587_/S VGND VGND VPWR VPWR _1955_/D sky130_fd_sc_hd__mux2_1
Xhold147 _1958_/Q VGND VGND VPWR VPWR hold147/X sky130_fd_sc_hd__dlygate4sd3_1
Xhold136 _1975_/Q VGND VGND VPWR VPWR hold136/X sky130_fd_sc_hd__dlygate4sd3_1
Xhold158 _1953_/Q VGND VGND VPWR VPWR hold158/X sky130_fd_sc_hd__dlygate4sd3_1
XFILLER_26_235 VGND VGND VPWR VPWR sky130_fd_sc_hd__decap_3
XFILLER_26_202 VGND VGND VPWR VPWR sky130_fd_sc_hd__decap_3
XTAP_TAPCELL_ROW_5_139 VGND VPWR sky130_fd_sc_hd__tapvpwrvgnd_1
XFILLER_26_268 VGND VGND VPWR VPWR sky130_fd_sc_hd__decap_3
XTAP_TAPCELL_ROW_27_263 VGND VPWR sky130_fd_sc_hd__tapvpwrvgnd_1
XFILLER_17_202 VGND VGND VPWR VPWR sky130_fd_sc_hd__fill_2
XTAP_TAPCELL_ROW_19_219 VGND VPWR sky130_fd_sc_hd__tapvpwrvgnd_1
X_1441_ _1441_/A _1441_/B VGND VGND VPWR VPWR _1443_/B sky130_fd_sc_hd__or2_2
X_1510_ _1770_/B _1598_/A VGND VGND VPWR VPWR _1510_/X sky130_fd_sc_hd__and2_2
XFILLER_4_161 VGND VGND VPWR VPWR sky130_fd_sc_hd__fill_2
XFILLER_4_32 VGND VGND VPWR VPWR sky130_fd_sc_hd__decap_3
X_1372_ _1882_/Q _1377_/B _1371_/Y _1407_/C1 VGND VGND VPWR VPWR _1882_/D sky130_fd_sc_hd__o211a_2
XFILLER_23_205 VGND VGND VPWR VPWR sky130_fd_sc_hd__decap_3
X_1708_ _2059_/Q _1709_/B _1707_/X _1779_/B1 VGND VGND VPWR VPWR _2022_/D sky130_fd_sc_hd__o211a_2
X_1639_ _1489_/Y _1515_/X _1640_/B _1638_/X VGND VGND VPWR VPWR _1987_/D sky130_fd_sc_hd__a31o_2
XTAP_TAPCELL_ROW_1_120 VGND VPWR sky130_fd_sc_hd__tapvpwrvgnd_1
Xfanout75 _1909_/Q VGND VGND VPWR VPWR _1832_/A0 sky130_fd_sc_hd__clkdlybuf4s25_1
Xfanout31 _1356_/B VGND VGND VPWR VPWR _1352_/B sky130_fd_sc_hd__clkdlybuf4s25_1
Xfanout42 _1441_/B VGND VGND VPWR VPWR _1337_/B2 sky130_fd_sc_hd__clkdlybuf4s25_1
Xfanout53 _2095_/Q VGND VGND VPWR VPWR _2093_/D sky130_fd_sc_hd__clkdlybuf4s25_1
Xfanout86 _1837_/C VGND VGND VPWR VPWR _1395_/C1 sky130_fd_sc_hd__clkdlybuf4s25_1
XTAP_TAPCELL_ROW_24_244 VGND VPWR sky130_fd_sc_hd__tapvpwrvgnd_1
Xfanout64 _2044_/Q VGND VGND VPWR VPWR _1756_/A sky130_fd_sc_hd__clkdlybuf4s25_1
Xfanout20 _1686_/X VGND VGND VPWR VPWR _1709_/B sky130_fd_sc_hd__clkdlybuf4s25_1
XFILLER_22_293 VGND VGND VPWR VPWR sky130_fd_sc_hd__decap_3
XFILLER_49_113 VGND VGND VPWR VPWR sky130_fd_sc_hd__fill_1
XFILLER_38_82 VGND VGND VPWR VPWR sky130_fd_sc_hd__fill_2
X_1990_ _2001_/CLK _1990_/D VGND VGND VPWR VPWR _1990_/Q sky130_fd_sc_hd__dfxtp_2
X_0941_ _0943_/C _0941_/B VGND VGND VPWR VPWR _2081_/D sky130_fd_sc_hd__nor2_2
XFILLER_20_208 VGND VGND VPWR VPWR sky130_fd_sc_hd__decap_3
X_1424_ _1904_/Q _1424_/B VGND VGND VPWR VPWR _1431_/B sky130_fd_sc_hd__and2b_2
X_1355_ _1874_/Q _1356_/B _1354_/Y _1403_/C1 VGND VGND VPWR VPWR _1874_/D sky130_fd_sc_hd__o211a_2
XTAP_TAPCELL_ROW_38_325 VGND VPWR sky130_fd_sc_hd__tapvpwrvgnd_1
X_1286_ _1294_/B _1284_/X _1285_/X _1271_/X VGND VGND VPWR VPWR _1286_/Y sky130_fd_sc_hd__a211oi_2
XFILLER_34_29 VGND VGND VPWR VPWR sky130_fd_sc_hd__decap_3
XFILLER_11_219 VGND VGND VPWR VPWR sky130_fd_sc_hd__decap_3
Xclkload6 clkload6/A VGND VGND VPWR VPWR clkload6/X sky130_fd_sc_hd__clkbuf_4
XFILLER_6_256 VGND VGND VPWR VPWR sky130_fd_sc_hd__fill_2
XFILLER_10_274 VGND VGND VPWR VPWR sky130_fd_sc_hd__decap_3
XFILLER_40_83 VGND VGND VPWR VPWR sky130_fd_sc_hd__fill_1
XTAP_TAPCELL_ROW_35_306 VGND VPWR sky130_fd_sc_hd__tapvpwrvgnd_1
X_1071_ _1265_/C _1263_/B _1041_/X VGND VGND VPWR VPWR _1235_/B sky130_fd_sc_hd__a21o_2
X_1140_ _1964_/Q _1968_/Q _1972_/Q _1976_/Q _1141_/S0 _1141_/S1 VGND VGND VPWR VPWR
+ _1140_/X sky130_fd_sc_hd__mux4_2
XTAP_TAPCELL_ROW_43_350 VGND VPWR sky130_fd_sc_hd__tapvpwrvgnd_1
X_0924_ _2023_/Q VGND VGND VPWR VPWR _1709_/A sky130_fd_sc_hd__inv_2
X_1973_ clkload0/A _1973_/D VGND VGND VPWR VPWR _1973_/Q sky130_fd_sc_hd__dfxtp_2
X_1407_ _1383_/A _1464_/A _1187_/Y _1406_/X _1407_/C1 VGND VGND VPWR VPWR _1899_/D
+ sky130_fd_sc_hd__o311a_2
X_1338_ _1371_/A1 _1337_/X _1342_/B VGND VGND VPWR VPWR _1338_/Y sky130_fd_sc_hd__o21ai_2
X_1269_ _1180_/A _1180_/B _1180_/C _1268_/X VGND VGND VPWR VPWR _1269_/X sky130_fd_sc_hd__a31o_2
XFILLER_34_119 VGND VGND VPWR VPWR sky130_fd_sc_hd__decap_3
XFILLER_27_160 VGND VGND VPWR VPWR sky130_fd_sc_hd__fill_1
XFILLER_19_116 VGND VGND VPWR VPWR sky130_fd_sc_hd__fill_1
XFILLER_42_141 VGND VGND VPWR VPWR sky130_fd_sc_hd__decap_3
XTAP_TAPCELL_ROW_40_331 VGND VPWR sky130_fd_sc_hd__tapvpwrvgnd_1
XFILLER_27_182 VGND VGND VPWR VPWR sky130_fd_sc_hd__decap_3
XFILLER_15_322 VGND VGND VPWR VPWR sky130_fd_sc_hd__fill_2
X_1123_ _1917_/Q _1921_/Q _1925_/Q _1929_/Q _1144_/S0 _1144_/S1 VGND VGND VPWR VPWR
+ _1123_/X sky130_fd_sc_hd__mux4_2
X_1054_ _2030_/Q _1159_/A VGND VGND VPWR VPWR _1054_/X sky130_fd_sc_hd__and2b_2
X_1887_ _1899_/CLK _1887_/D VGND VGND VPWR VPWR _1887_/Q sky130_fd_sc_hd__dfxtp_2
X_1956_ clkload0/A _1956_/D VGND VGND VPWR VPWR _1956_/Q sky130_fd_sc_hd__dfxtp_2
XFILLER_0_218 VGND VGND VPWR VPWR sky130_fd_sc_hd__decap_3
XFILLER_24_141 VGND VGND VPWR VPWR sky130_fd_sc_hd__fill_2
XFILLER_8_307 VGND VGND VPWR VPWR sky130_fd_sc_hd__fill_1
XFILLER_12_303 VGND VGND VPWR VPWR sky130_fd_sc_hd__decap_3
XFILLER_47_288 VGND VGND VPWR VPWR sky130_fd_sc_hd__fill_2
X_1741_ hold119/X _1739_/A _1740_/Y VGND VGND VPWR VPWR _2037_/D sky130_fd_sc_hd__a21oi_2
XFILLER_7_54 VGND VGND VPWR VPWR sky130_fd_sc_hd__fill_2
X_1810_ _2071_/Q _2093_/D VGND VGND VPWR VPWR _1810_/X sky130_fd_sc_hd__or2_2
X_1672_ _2005_/Q _1622_/B _1674_/S VGND VGND VPWR VPWR _2005_/D sky130_fd_sc_hd__mux2_1
X_1106_ _1986_/Q _1138_/A2 _1138_/B1 _1990_/Q _1136_/A VGND VGND VPWR VPWR _1106_/X
+ sky130_fd_sc_hd__a221o_2
X_2086_ fanout93/X _2086_/D osc_en VGND VGND VPWR VPWR _2086_/Q sky130_fd_sc_hd__dfrtp_2
X_1037_ _1038_/A _1152_/A VGND VGND VPWR VPWR _1037_/Y sky130_fd_sc_hd__nand2_2
X_1939_ _2036_/CLK _1939_/D VGND VGND VPWR VPWR _1939_/Q sky130_fd_sc_hd__dfxtp_2
XTAP_TAPCELL_ROW_8_159 VGND VPWR sky130_fd_sc_hd__tapvpwrvgnd_1
XFILLER_44_203 VGND VGND VPWR VPWR sky130_fd_sc_hd__fill_1
XFILLER_29_299 VGND VGND VPWR VPWR sky130_fd_sc_hd__decap_3
XFILLER_8_159 VGND VGND VPWR VPWR sky130_fd_sc_hd__decap_3
XPHY_EDGE_ROW_11_Right_11 VGND VGND VPWR VPWR sky130_fd_sc_hd__decap_3
XFILLER_16_85 VGND VGND VPWR VPWR sky130_fd_sc_hd__decap_3
XFILLER_4_321 VGND VGND VPWR VPWR sky130_fd_sc_hd__decap_3
XPHY_EDGE_ROW_20_Right_20 VGND VGND VPWR VPWR sky130_fd_sc_hd__decap_3
XFILLER_35_225 VGND VGND VPWR VPWR sky130_fd_sc_hd__decap_3
Xhold115 _2102_/Q VGND VGND VPWR VPWR _2103_/D sky130_fd_sc_hd__dlygate4sd3_1
Xhold126 _1944_/Q VGND VGND VPWR VPWR hold126/X sky130_fd_sc_hd__dlygate4sd3_1
X_1724_ _2055_/Q _1724_/B VGND VGND VPWR VPWR _1724_/Y sky130_fd_sc_hd__nand2b_2
XTAP_TAPCELL_ROW_13_183 VGND VPWR sky130_fd_sc_hd__tapvpwrvgnd_1
Xhold137 _2112_/Q VGND VGND VPWR VPWR hold137/X sky130_fd_sc_hd__dlygate4sd3_1
X_1655_ _1655_/A _1670_/B VGND VGND VPWR VPWR _1659_/S sky130_fd_sc_hd__nor2_2
X_1586_ hold166/X _1770_/B _1587_/S VGND VGND VPWR VPWR _1954_/D sky130_fd_sc_hd__mux2_1
Xhold148 _1952_/Q VGND VGND VPWR VPWR hold148/X sky130_fd_sc_hd__dlygate4sd3_1
Xhold159 _1968_/Q VGND VGND VPWR VPWR hold159/X sky130_fd_sc_hd__dlygate4sd3_1
X_2069_ clkload1/A _2069_/D VGND VGND VPWR VPWR _2069_/Q sky130_fd_sc_hd__dfxtp_2
XFILLER_41_228 VGND VGND VPWR VPWR sky130_fd_sc_hd__fill_1
XFILLER_32_206 VGND VGND VPWR VPWR sky130_fd_sc_hd__fill_2
XTAP_TAPCELL_ROW_27_264 VGND VPWR sky130_fd_sc_hd__tapvpwrvgnd_1
XFILLER_27_95 VGND VGND VPWR VPWR sky130_fd_sc_hd__decap_3
XFILLER_27_84 VGND VGND VPWR VPWR sky130_fd_sc_hd__fill_2
XFILLER_17_225 VGND VGND VPWR VPWR sky130_fd_sc_hd__decap_3
XFILLER_40_294 VGND VGND VPWR VPWR sky130_fd_sc_hd__decap_3
XFILLER_40_283 VGND VGND VPWR VPWR sky130_fd_sc_hd__fill_1
X_1440_ _1440_/A _1440_/B VGND VGND VPWR VPWR _1906_/D sky130_fd_sc_hd__nor2_2
X_1371_ _1371_/A1 _1337_/X _1377_/B VGND VGND VPWR VPWR _1371_/Y sky130_fd_sc_hd__o21ai_2
XFILLER_4_44 VGND VGND VPWR VPWR sky130_fd_sc_hd__fill_2
XFILLER_23_217 VGND VGND VPWR VPWR sky130_fd_sc_hd__fill_2
X_1638_ _1987_/Q _1638_/B VGND VGND VPWR VPWR _1638_/X sky130_fd_sc_hd__and2_2
X_1707_ _2022_/Q _1707_/B VGND VGND VPWR VPWR _1707_/X sky130_fd_sc_hd__or2_2
X_1569_ hold120/X _1563_/X _1568_/Y VGND VGND VPWR VPWR _1946_/D sky130_fd_sc_hd__a21o_2
Xfanout21 _1516_/B VGND VGND VPWR VPWR _1598_/A sky130_fd_sc_hd__clkdlybuf4s25_1
XTAP_TAPCELL_ROW_1_121 VGND VPWR sky130_fd_sc_hd__tapvpwrvgnd_1
XFILLER_14_206 VGND VGND VPWR VPWR sky130_fd_sc_hd__decap_3
Xfanout10 _1179_/X VGND VGND VPWR VPWR _1279_/A1 sky130_fd_sc_hd__clkdlybuf4s25_1
Xfanout65 _1910_/Q VGND VGND VPWR VPWR _1141_/S1 sky130_fd_sc_hd__clkdlybuf4s25_1
Xfanout43 _1001_/X VGND VGND VPWR VPWR _1441_/B sky130_fd_sc_hd__clkdlybuf4s25_1
Xfanout32 _1332_/Y VGND VGND VPWR VPWR _1356_/B sky130_fd_sc_hd__clkdlybuf4s25_1
Xfanout87 _1846_/C VGND VGND VPWR VPWR _1389_/C1 sky130_fd_sc_hd__clkdlybuf4s25_1
Xfanout54 _2064_/Q VGND VGND VPWR VPWR _1796_/B sky130_fd_sc_hd__clkdlybuf4s25_1
XTAP_TAPCELL_ROW_24_245 VGND VPWR sky130_fd_sc_hd__tapvpwrvgnd_1
X_0940_ _2081_/Q _0940_/B VGND VGND VPWR VPWR _0941_/B sky130_fd_sc_hd__nor2_2
XFILLER_9_276 VGND VGND VPWR VPWR sky130_fd_sc_hd__decap_3
XFILLER_9_287 VGND VGND VPWR VPWR sky130_fd_sc_hd__fill_2
XPHY_EDGE_ROW_50_Left_103 VGND VGND VPWR VPWR sky130_fd_sc_hd__decap_3
X_1423_ _1422_/X _1831_/C _1423_/C VGND VGND VPWR VPWR _1903_/D sky130_fd_sc_hd__and3b_2
X_1354_ _1404_/A _1356_/B VGND VGND VPWR VPWR _1354_/Y sky130_fd_sc_hd__nand2_2
X_1285_ _2015_/Q _1306_/A _1302_/A _2014_/Q VGND VGND VPWR VPWR _1285_/X sky130_fd_sc_hd__o211a_2
XFILLER_51_323 VGND VGND VPWR VPWR sky130_fd_sc_hd__fill_1
XFILLER_36_320 VGND VGND VPWR VPWR sky130_fd_sc_hd__decap_3
Xclkload7 clkload7/A VGND VGND VPWR VPWR clkload7/Y sky130_fd_sc_hd__clkinv_4
XFILLER_1_9 VGND VGND VPWR VPWR sky130_fd_sc_hd__fill_2
XFILLER_27_320 VGND VGND VPWR VPWR sky130_fd_sc_hd__decap_3
XFILLER_6_235 VGND VGND VPWR VPWR sky130_fd_sc_hd__fill_1
XFILLER_6_279 VGND VGND VPWR VPWR sky130_fd_sc_hd__decap_3
XFILLER_10_231 VGND VGND VPWR VPWR sky130_fd_sc_hd__decap_3
XFILLER_10_253 VGND VGND VPWR VPWR sky130_fd_sc_hd__decap_3
XFILLER_10_286 VGND VGND VPWR VPWR sky130_fd_sc_hd__decap_3
XFILLER_37_106 VGND VGND VPWR VPWR sky130_fd_sc_hd__decap_3
XTAP_TAPCELL_ROW_35_307 VGND VPWR sky130_fd_sc_hd__tapvpwrvgnd_1
X_1070_ _1265_/C _1263_/B VGND VGND VPWR VPWR _1264_/A sky130_fd_sc_hd__and2_2
XFILLER_18_320 VGND VGND VPWR VPWR sky130_fd_sc_hd__decap_3
XTAP_TAPCELL_ROW_43_351 VGND VPWR sky130_fd_sc_hd__tapvpwrvgnd_1
X_0923_ _2024_/Q VGND VGND VPWR VPWR _1079_/A sky130_fd_sc_hd__inv_2
X_1972_ _2064_/CLK _1972_/D VGND VGND VPWR VPWR _1972_/Q sky130_fd_sc_hd__dfxtp_2
XPHY_EDGE_ROW_49_Right_49 VGND VGND VPWR VPWR sky130_fd_sc_hd__decap_3
XFILLER_5_290 VGND VGND VPWR VPWR sky130_fd_sc_hd__decap_3
X_1406_ _1899_/Q _1406_/B VGND VGND VPWR VPWR _1406_/X sky130_fd_sc_hd__or2_2
X_1337_ _1337_/A1 _1396_/A _1404_/A _1337_/B2 _1303_/X VGND VGND VPWR VPWR _1337_/X
+ sky130_fd_sc_hd__a221o_2
XFILLER_28_139 VGND VGND VPWR VPWR sky130_fd_sc_hd__fill_1
X_1268_ _1268_/A _1268_/B VGND VGND VPWR VPWR _1268_/X sky130_fd_sc_hd__xor2_2
XFILLER_24_323 VGND VGND VPWR VPWR sky130_fd_sc_hd__fill_1
X_1199_ _1180_/X _1198_/Y _1279_/A1 VGND VGND VPWR VPWR _1199_/X sky130_fd_sc_hd__o21a_2
XFILLER_3_249 VGND VGND VPWR VPWR sky130_fd_sc_hd__decap_3
XFILLER_10_65 VGND VGND VPWR VPWR sky130_fd_sc_hd__fill_2
XFILLER_15_301 VGND VGND VPWR VPWR sky130_fd_sc_hd__decap_3
XTAP_TAPCELL_ROW_40_332 VGND VPWR sky130_fd_sc_hd__tapvpwrvgnd_1
X_1122_ _1933_/Q _1937_/Q _1941_/Q _1945_/Q _1144_/S0 _1144_/S1 VGND VGND VPWR VPWR
+ _1122_/X sky130_fd_sc_hd__mux4_2
XFILLER_2_282 VGND VGND VPWR VPWR sky130_fd_sc_hd__decap_3
X_1053_ _1245_/A _1245_/B _1245_/C VGND VGND VPWR VPWR _1227_/B sky130_fd_sc_hd__a21oi_2
X_1886_ _1897_/CLK _1886_/D VGND VGND VPWR VPWR _1886_/Q sky130_fd_sc_hd__dfxtp_2
X_1955_ _1963_/CLK _1955_/D VGND VGND VPWR VPWR _1955_/Q sky130_fd_sc_hd__dfxtp_2
XFILLER_24_197 VGND VGND VPWR VPWR sky130_fd_sc_hd__decap_3
XFILLER_21_53 VGND VGND VPWR VPWR sky130_fd_sc_hd__decap_3
XFILLER_15_131 VGND VGND VPWR VPWR sky130_fd_sc_hd__fill_2
XFILLER_15_186 VGND VGND VPWR VPWR sky130_fd_sc_hd__decap_3
X_1740_ _2137_/A _1739_/A _1736_/B VGND VGND VPWR VPWR _1740_/Y sky130_fd_sc_hd__o21ai_2
X_1671_ hold188/X _1620_/B _1674_/S VGND VGND VPWR VPWR _2004_/D sky130_fd_sc_hd__mux2_1
XFILLER_30_167 VGND VGND VPWR VPWR sky130_fd_sc_hd__decap_3
XFILLER_15_197 VGND VGND VPWR VPWR sky130_fd_sc_hd__decap_3
XFILLER_30_3 VGND VGND VPWR VPWR sky130_fd_sc_hd__fill_1
X_1105_ _1998_/Q _2002_/Q _2006_/Q _2010_/Q _1832_/A0 _1003_/B VGND VGND VPWR VPWR
+ _1105_/X sky130_fd_sc_hd__mux4_2
X_2085_ fanout93/X _2085_/D osc_en VGND VGND VPWR VPWR _2085_/Q sky130_fd_sc_hd__dfrtp_2
X_1036_ _1275_/B _1275_/A _1149_/A _2025_/Q VGND VGND VPWR VPWR _1258_/A sky130_fd_sc_hd__a2bb2o_2
XFILLER_21_156 VGND VGND VPWR VPWR sky130_fd_sc_hd__fill_1
X_1938_ _2036_/CLK _1938_/D VGND VGND VPWR VPWR _1938_/Q sky130_fd_sc_hd__dfxtp_2
X_1869_ clkload7/A _1869_/D VGND VGND VPWR VPWR _1869_/Q sky130_fd_sc_hd__dfxtp_2
XFILLER_29_223 VGND VGND VPWR VPWR sky130_fd_sc_hd__fill_1
XFILLER_29_212 VGND VGND VPWR VPWR sky130_fd_sc_hd__fill_2
XFILLER_32_85 VGND VGND VPWR VPWR sky130_fd_sc_hd__decap_3
XFILLER_16_97 VGND VGND VPWR VPWR sky130_fd_sc_hd__decap_3
XFILLER_35_237 VGND VGND VPWR VPWR sky130_fd_sc_hd__fill_2
Xhold116 _1947_/Q VGND VGND VPWR VPWR hold116/X sky130_fd_sc_hd__dlygate4sd3_1
Xhold127 _2003_/Q VGND VGND VPWR VPWR hold127/X sky130_fd_sc_hd__dlygate4sd3_1
Xhold138 _1937_/Q VGND VGND VPWR VPWR hold138/X sky130_fd_sc_hd__dlygate4sd3_1
X_1654_ hold122/X _1646_/X _1653_/Y VGND VGND VPWR VPWR _1995_/D sky130_fd_sc_hd__a21o_2
Xhold149 _1961_/Q VGND VGND VPWR VPWR hold149/X sky130_fd_sc_hd__dlygate4sd3_1
X_1723_ _2029_/Q _1724_/B _1722_/Y _1723_/C1 VGND VGND VPWR VPWR _2029_/D sky130_fd_sc_hd__o211a_2
XFILLER_7_193 VGND VGND VPWR VPWR sky130_fd_sc_hd__decap_3
XTAP_TAPCELL_ROW_13_184 VGND VPWR sky130_fd_sc_hd__tapvpwrvgnd_1
X_1585_ hold158/X _2050_/Q _1587_/S VGND VGND VPWR VPWR _1953_/D sky130_fd_sc_hd__mux2_1
X_2137_ _2137_/A VGND VGND VPWR VPWR uo_out[7] sky130_fd_sc_hd__buf_2
X_1019_ _2029_/Q _1158_/A VGND VGND VPWR VPWR _1227_/A sky130_fd_sc_hd__and2_2
X_2068_ _2068_/CLK _2068_/D VGND VGND VPWR VPWR _2068_/Q sky130_fd_sc_hd__dfxtp_2
XFILLER_5_108 VGND VGND VPWR VPWR sky130_fd_sc_hd__decap_3
XPHY_EDGE_ROW_36_Left_89 VGND VGND VPWR VPWR sky130_fd_sc_hd__decap_3
XFILLER_17_237 VGND VGND VPWR VPWR sky130_fd_sc_hd__decap_3
XFILLER_40_251 VGND VGND VPWR VPWR sky130_fd_sc_hd__fill_1
XFILLER_25_292 VGND VGND VPWR VPWR sky130_fd_sc_hd__decap_3
X_1370_ _1881_/Q _1377_/B _1369_/Y _1395_/C1 VGND VGND VPWR VPWR _1881_/D sky130_fd_sc_hd__o211a_2
XFILLER_4_152 VGND VGND VPWR VPWR sky130_fd_sc_hd__decap_3
XTAP_TAPCELL_ROW_18_210 VGND VPWR sky130_fd_sc_hd__tapvpwrvgnd_1
XFILLER_31_251 VGND VGND VPWR VPWR sky130_fd_sc_hd__decap_3
XFILLER_31_240 VGND VGND VPWR VPWR sky130_fd_sc_hd__decap_3
XFILLER_16_292 VGND VGND VPWR VPWR sky130_fd_sc_hd__fill_2
X_1637_ _1489_/Y _1510_/X _1640_/B _1636_/X VGND VGND VPWR VPWR _1986_/D sky130_fd_sc_hd__a31o_2
X_1706_ _2058_/Q _1709_/B _1705_/Y _1779_/B1 VGND VGND VPWR VPWR _2021_/D sky130_fd_sc_hd__o211a_2
X_1568_ _1681_/A _1570_/B VGND VGND VPWR VPWR _1568_/Y sky130_fd_sc_hd__nor2_2
X_1499_ _1796_/B _1619_/B VGND VGND VPWR VPWR _1500_/B sky130_fd_sc_hd__nand2_2
Xfanout44 _0999_/X VGND VGND VPWR VPWR _1138_/A2 sky130_fd_sc_hd__clkdlybuf4s25_1
Xfanout55 _2064_/Q VGND VGND VPWR VPWR _1676_/A sky130_fd_sc_hd__clkdlybuf4s25_1
XTAP_TAPCELL_ROW_24_246 VGND VPWR sky130_fd_sc_hd__tapvpwrvgnd_1
Xfanout22 _1172_/B VGND VGND VPWR VPWR _1160_/B sky130_fd_sc_hd__clkdlybuf4s25_1
Xfanout11 _1177_/Y VGND VGND VPWR VPWR _1180_/B sky130_fd_sc_hd__clkdlybuf4s25_1
XFILLER_14_229 VGND VGND VPWR VPWR sky130_fd_sc_hd__decap_3
Xfanout88 _1837_/C VGND VGND VPWR VPWR _1846_/C sky130_fd_sc_hd__clkdlybuf4s25_1
Xfanout66 _1910_/Q VGND VGND VPWR VPWR _1144_/S1 sky130_fd_sc_hd__clkdlybuf4s25_1
XTAP_TAPCELL_ROW_32_290 VGND VPWR sky130_fd_sc_hd__tapvpwrvgnd_1
Xfanout77 _1811_/B1 VGND VGND VPWR VPWR _1789_/B1 sky130_fd_sc_hd__clkdlybuf4s25_1
XFILLER_22_273 VGND VGND VPWR VPWR sky130_fd_sc_hd__decap_3
XFILLER_9_222 VGND VGND VPWR VPWR sky130_fd_sc_hd__fill_2
XFILLER_9_233 VGND VGND VPWR VPWR sky130_fd_sc_hd__decap_3
X_1422_ _1903_/Q _1902_/Q _1846_/D VGND VGND VPWR VPWR _1422_/X sky130_fd_sc_hd__and3_2
XFILLER_9_299 VGND VGND VPWR VPWR sky130_fd_sc_hd__decap_3
XFILLER_48_170 VGND VGND VPWR VPWR sky130_fd_sc_hd__fill_1
X_1353_ _1873_/Q _1352_/B _1352_/Y _1403_/C1 VGND VGND VPWR VPWR _1873_/D sky130_fd_sc_hd__o211a_2
X_1284_ _1283_/A _1283_/B _1280_/X VGND VGND VPWR VPWR _1284_/X sky130_fd_sc_hd__a21o_2
Xclkload8 clkload8/A VGND VGND VPWR VPWR clkload8/X sky130_fd_sc_hd__clkbuf_4
X_0999_ _1003_/B _1449_/A VGND VGND VPWR VPWR _0999_/X sky130_fd_sc_hd__and2b_2
XTAP_TAPCELL_ROW_21_227 VGND VPWR sky130_fd_sc_hd__tapvpwrvgnd_1
XFILLER_40_96 VGND VGND VPWR VPWR sky130_fd_sc_hd__fill_2
XFILLER_40_85 VGND VGND VPWR VPWR sky130_fd_sc_hd__decap_3
XFILLER_6_203 VGND VGND VPWR VPWR sky130_fd_sc_hd__fill_1
XFILLER_6_225 VGND VGND VPWR VPWR sky130_fd_sc_hd__fill_2
XPHY_EDGE_ROW_39_Left_92 VGND VGND VPWR VPWR sky130_fd_sc_hd__decap_3
XTAP_TAPCELL_ROW_43_352 VGND VPWR sky130_fd_sc_hd__tapvpwrvgnd_1
XTAP_TAPCELL_ROW_35_308 VGND VPWR sky130_fd_sc_hd__tapvpwrvgnd_1
XPHY_EDGE_ROW_23_Left_76 VGND VGND VPWR VPWR sky130_fd_sc_hd__decap_3
XFILLER_1_57 VGND VGND VPWR VPWR sky130_fd_sc_hd__decap_3
X_0922_ _2026_/Q VGND VGND VPWR VPWR _1038_/A sky130_fd_sc_hd__inv_2
X_1971_ _2077_/CLK _1971_/D VGND VGND VPWR VPWR _1971_/Q sky130_fd_sc_hd__dfxtp_2
X_1405_ _1898_/Q _1406_/B _1404_/Y _1407_/C1 VGND VGND VPWR VPWR _1898_/D sky130_fd_sc_hd__o211a_2
XFILLER_28_107 VGND VGND VPWR VPWR sky130_fd_sc_hd__fill_2
X_1336_ _1865_/Q _1342_/B _1335_/Y _1389_/C1 VGND VGND VPWR VPWR _1865_/D sky130_fd_sc_hd__o211a_2
Xinput1 osc_in VGND VGND VPWR VPWR input1/X sky130_fd_sc_hd__clkdlybuf4s25_1
X_1267_ _1267_/A _1267_/B VGND VGND VPWR VPWR _1268_/B sky130_fd_sc_hd__nand2_2
X_1198_ _1198_/A _1198_/B VGND VGND VPWR VPWR _1198_/Y sky130_fd_sc_hd__xnor2_2
XFILLER_36_184 VGND VGND VPWR VPWR sky130_fd_sc_hd__decap_3
XFILLER_3_228 VGND VGND VPWR VPWR sky130_fd_sc_hd__decap_3
XFILLER_3_206 VGND VGND VPWR VPWR sky130_fd_sc_hd__fill_1
XFILLER_35_63 VGND VGND VPWR VPWR sky130_fd_sc_hd__decap_3
XFILLER_35_52 VGND VGND VPWR VPWR sky130_fd_sc_hd__decap_3
XFILLER_51_84 VGND VGND VPWR VPWR sky130_fd_sc_hd__fill_2
XTAP_TAPCELL_ROW_40_333 VGND VPWR sky130_fd_sc_hd__tapvpwrvgnd_1
X_1121_ _1120_/X _1119_/X _1145_/S VGND VGND VPWR VPWR _1121_/X sky130_fd_sc_hd__mux2_1
XFILLER_25_6 VGND VGND VPWR VPWR sky130_fd_sc_hd__fill_1
X_1052_ _1227_/A _1052_/B VGND VGND VPWR VPWR _1245_/C sky130_fd_sc_hd__or2_2
XFILLER_33_143 VGND VGND VPWR VPWR sky130_fd_sc_hd__fill_1
X_1954_ clkload0/A _1954_/D VGND VGND VPWR VPWR _1954_/Q sky130_fd_sc_hd__dfxtp_2
XFILLER_18_195 VGND VGND VPWR VPWR sky130_fd_sc_hd__fill_1
XFILLER_21_305 VGND VGND VPWR VPWR sky130_fd_sc_hd__fill_1
X_1885_ _1897_/CLK _1885_/D VGND VGND VPWR VPWR _1885_/Q sky130_fd_sc_hd__dfxtp_2
X_1319_ _1325_/A _1398_/A VGND VGND VPWR VPWR _1319_/Y sky130_fd_sc_hd__nand2_2
XFILLER_24_187 VGND VGND VPWR VPWR sky130_fd_sc_hd__fill_1
XFILLER_8_309 VGND VGND VPWR VPWR sky130_fd_sc_hd__fill_2
X_1670_ _1670_/A _1670_/B VGND VGND VPWR VPWR _1674_/S sky130_fd_sc_hd__nor2_2
XFILLER_7_320 VGND VGND VPWR VPWR sky130_fd_sc_hd__decap_3
XFILLER_38_202 VGND VGND VPWR VPWR sky130_fd_sc_hd__decap_3
XFILLER_23_3 VGND VGND VPWR VPWR sky130_fd_sc_hd__decap_3
X_2084_ fanout94/X _2084_/D osc_en VGND VGND VPWR VPWR _2084_/Q sky130_fd_sc_hd__dfrtp_2
X_1104_ _1104_/A _1160_/B VGND VGND VPWR VPWR _1267_/B sky130_fd_sc_hd__nand2_2
X_1035_ _2025_/Q _1149_/A VGND VGND VPWR VPWR _1275_/B sky130_fd_sc_hd__xnor2_2
X_1937_ _2036_/CLK _1937_/D VGND VGND VPWR VPWR _1937_/Q sky130_fd_sc_hd__dfxtp_2
XFILLER_21_179 VGND VGND VPWR VPWR sky130_fd_sc_hd__fill_2
X_1868_ clkload6/A _1868_/D VGND VGND VPWR VPWR _1868_/Q sky130_fd_sc_hd__dfxtp_2
XPHY_EDGE_ROW_10_Left_63 VGND VGND VPWR VPWR sky130_fd_sc_hd__decap_3
X_1799_ _1807_/A1 _1796_/B _1805_/B1 _1798_/X VGND VGND VPWR VPWR _2065_/D sky130_fd_sc_hd__o211a_2
XFILLER_12_113 VGND VGND VPWR VPWR sky130_fd_sc_hd__fill_2
XFILLER_16_43 VGND VGND VPWR VPWR sky130_fd_sc_hd__decap_3
XFILLER_4_312 VGND VGND VPWR VPWR sky130_fd_sc_hd__decap_3
XFILLER_12_146 VGND VGND VPWR VPWR sky130_fd_sc_hd__fill_2
XFILLER_12_179 VGND VGND VPWR VPWR sky130_fd_sc_hd__decap_3
XTAP_TAPCELL_ROW_7_150 VGND VPWR sky130_fd_sc_hd__tapvpwrvgnd_1
Xhold139 _2111_/Q VGND VGND VPWR VPWR hold139/X sky130_fd_sc_hd__dlygate4sd3_1
Xhold117 _2010_/Q VGND VGND VPWR VPWR hold117/X sky130_fd_sc_hd__dlygate4sd3_1
Xhold128 _1936_/Q VGND VGND VPWR VPWR hold128/X sky130_fd_sc_hd__dlygate4sd3_1
X_1653_ _1683_/A _1653_/B VGND VGND VPWR VPWR _1653_/Y sky130_fd_sc_hd__nor2_2
X_1584_ hold148/X _2049_/Q _1587_/S VGND VGND VPWR VPWR _1952_/D sky130_fd_sc_hd__mux2_1
X_1722_ _2054_/Q _1724_/B VGND VGND VPWR VPWR _1722_/Y sky130_fd_sc_hd__nand2b_2
XPHY_EDGE_ROW_9_Right_9 VGND VGND VPWR VPWR sky130_fd_sc_hd__decap_3
XTAP_TAPCELL_ROW_13_185 VGND VPWR sky130_fd_sc_hd__tapvpwrvgnd_1
XFILLER_41_208 VGND VGND VPWR VPWR sky130_fd_sc_hd__decap_3
XFILLER_26_238 VGND VGND VPWR VPWR sky130_fd_sc_hd__decap_3
XFILLER_26_216 VGND VGND VPWR VPWR sky130_fd_sc_hd__decap_3
XFILLER_26_205 VGND VGND VPWR VPWR sky130_fd_sc_hd__decap_3
X_2136_ por_n_in VGND VGND VPWR VPWR uo_out[6] sky130_fd_sc_hd__buf_2
X_2067_ _2068_/CLK _2067_/D VGND VGND VPWR VPWR _2067_/Q sky130_fd_sc_hd__dfxtp_2
X_1018_ _1857_/Q _1371_/A1 _1337_/B2 _1893_/Q _1017_/X VGND VGND VPWR VPWR _1158_/A
+ sky130_fd_sc_hd__a221o_2
XFILLER_43_74 VGND VGND VPWR VPWR sky130_fd_sc_hd__fill_1
XTAP_TAPCELL_ROW_10_166 VGND VPWR sky130_fd_sc_hd__tapvpwrvgnd_1
XFILLER_4_35 VGND VGND VPWR VPWR sky130_fd_sc_hd__decap_3
XFILLER_23_208 VGND VGND VPWR VPWR sky130_fd_sc_hd__fill_1
XTAP_TAPCELL_ROW_18_211 VGND VPWR sky130_fd_sc_hd__tapvpwrvgnd_1
X_1705_ _1705_/A _1709_/B VGND VGND VPWR VPWR _1705_/Y sky130_fd_sc_hd__nand2_2
X_1567_ hold118/X _1563_/X _1566_/Y VGND VGND VPWR VPWR _1945_/D sky130_fd_sc_hd__a21o_2
X_1636_ _1986_/Q _1638_/B VGND VGND VPWR VPWR _1636_/X sky130_fd_sc_hd__and2_2
X_1498_ _1920_/Q _1514_/B VGND VGND VPWR VPWR _1498_/X sky130_fd_sc_hd__and2_2
Xfanout67 _1910_/Q VGND VGND VPWR VPWR _1028_/A sky130_fd_sc_hd__clkdlybuf4s25_1
Xfanout45 _0996_/Y VGND VGND VPWR VPWR _1137_/A2 sky130_fd_sc_hd__clkdlybuf4s25_1
Xfanout89 _1407_/C1 VGND VGND VPWR VPWR _1403_/C1 sky130_fd_sc_hd__clkdlybuf4s25_1
Xfanout34 _1330_/B VGND VGND VPWR VPWR _1310_/A sky130_fd_sc_hd__clkdlybuf4s25_1
XTAP_TAPCELL_ROW_24_247 VGND VPWR sky130_fd_sc_hd__tapvpwrvgnd_1
Xfanout78 _1811_/B1 VGND VGND VPWR VPWR _1779_/B1 sky130_fd_sc_hd__clkdlybuf4s25_1
Xfanout23 _1178_/B VGND VGND VPWR VPWR _1172_/B sky130_fd_sc_hd__clkdlybuf4s25_1
Xfanout56 _2063_/Q VGND VGND VPWR VPWR _1794_/B sky130_fd_sc_hd__clkdlybuf4s25_1
XTAP_TAPCELL_ROW_32_291 VGND VPWR sky130_fd_sc_hd__tapvpwrvgnd_1
XFILLER_22_296 VGND VGND VPWR VPWR sky130_fd_sc_hd__decap_3
XFILLER_45_300 VGND VGND VPWR VPWR sky130_fd_sc_hd__fill_1
X_1421_ _1902_/Q _1846_/D _1903_/Q VGND VGND VPWR VPWR _1423_/C sky130_fd_sc_hd__a21o_2
X_1352_ _1402_/A _1352_/B VGND VGND VPWR VPWR _1352_/Y sky130_fd_sc_hd__nand2_2
X_1283_ _1283_/A _1283_/B VGND VGND VPWR VPWR _1294_/C sky130_fd_sc_hd__and2_2
Xclkload9 clkload9/A VGND VGND VPWR VPWR clkload9/X sky130_fd_sc_hd__clkbuf_4
X_0998_ _1383_/A _1457_/A VGND VGND VPWR VPWR _0998_/Y sky130_fd_sc_hd__nor2_2
XTAP_TAPCELL_ROW_21_228 VGND VPWR sky130_fd_sc_hd__tapvpwrvgnd_1
X_1619_ _1796_/B _1619_/B _1628_/A _2065_/Q VGND VGND VPWR VPWR _1619_/X sky130_fd_sc_hd__or4b_2
XTAP_TAPCELL_ROW_52_397 VGND VPWR sky130_fd_sc_hd__tapvpwrvgnd_1
XFILLER_10_211 VGND VGND VPWR VPWR sky130_fd_sc_hd__fill_2
XFILLER_10_277 VGND VGND VPWR VPWR sky130_fd_sc_hd__decap_3
XFILLER_18_300 VGND VGND VPWR VPWR sky130_fd_sc_hd__decap_3
X_1970_ clkload0/A _1970_/D VGND VGND VPWR VPWR _1970_/Q sky130_fd_sc_hd__dfxtp_2
X_0921_ _2048_/Q VGND VGND VPWR VPWR _1764_/A sky130_fd_sc_hd__inv_2
X_1404_ _1404_/A _1406_/B VGND VGND VPWR VPWR _1404_/Y sky130_fd_sc_hd__nand2_2
X_1335_ _1386_/A _1342_/B VGND VGND VPWR VPWR _1335_/Y sky130_fd_sc_hd__nand2_2
XFILLER_5_281 VGND VGND VPWR VPWR sky130_fd_sc_hd__decap_3
Xinput2 rst_n VGND VGND VPWR VPWR input2/X sky130_fd_sc_hd__clkdlybuf4s25_1
XFILLER_36_141 VGND VGND VPWR VPWR sky130_fd_sc_hd__decap_3
X_1266_ _1044_/Y _1228_/B _1265_/X _1266_/B1 VGND VGND VPWR VPWR _1266_/X sky130_fd_sc_hd__o31a_2
X_1197_ _1206_/A _1206_/B _1190_/B VGND VGND VPWR VPWR _1198_/B sky130_fd_sc_hd__a21o_2
XPHY_EDGE_ROW_40_Left_93 VGND VGND VPWR VPWR sky130_fd_sc_hd__decap_3
XFILLER_42_177 VGND VGND VPWR VPWR sky130_fd_sc_hd__decap_3
XFILLER_42_144 VGND VGND VPWR VPWR sky130_fd_sc_hd__fill_1
XFILLER_42_100 VGND VGND VPWR VPWR sky130_fd_sc_hd__fill_1
XFILLER_30_317 VGND VGND VPWR VPWR sky130_fd_sc_hd__decap_3
XFILLER_27_141 VGND VGND VPWR VPWR sky130_fd_sc_hd__fill_1
XTAP_TAPCELL_ROW_40_334 VGND VPWR sky130_fd_sc_hd__tapvpwrvgnd_1
XFILLER_2_251 VGND VGND VPWR VPWR sky130_fd_sc_hd__fill_1
XFILLER_33_111 VGND VGND VPWR VPWR sky130_fd_sc_hd__fill_1
X_1120_ _1949_/Q _1953_/Q _1957_/Q _1961_/Q _1141_/S0 _1141_/S1 VGND VGND VPWR VPWR
+ _1120_/X sky130_fd_sc_hd__mux4_2
X_1051_ _2029_/Q _1158_/A VGND VGND VPWR VPWR _1052_/B sky130_fd_sc_hd__nor2_2
XFILLER_18_141 VGND VGND VPWR VPWR sky130_fd_sc_hd__decap_3
X_1884_ _1897_/CLK _1884_/D VGND VGND VPWR VPWR _1884_/Q sky130_fd_sc_hd__dfxtp_2
X_1953_ clkload0/A _1953_/D VGND VGND VPWR VPWR _1953_/Q sky130_fd_sc_hd__dfxtp_2
XPHY_EDGE_ROW_47_Left_100 VGND VGND VPWR VPWR sky130_fd_sc_hd__decap_3
X_1318_ _1318_/A _1327_/B _1327_/C VGND VGND VPWR VPWR _1398_/A sky130_fd_sc_hd__or3_2
X_1249_ _1249_/A _1249_/B VGND VGND VPWR VPWR _1249_/Y sky130_fd_sc_hd__xnor2_2
XFILLER_12_306 VGND VGND VPWR VPWR sky130_fd_sc_hd__fill_2
XFILLER_47_225 VGND VGND VPWR VPWR sky130_fd_sc_hd__fill_1
XFILLER_46_85 VGND VGND VPWR VPWR sky130_fd_sc_hd__decap_3
XFILLER_30_125 VGND VGND VPWR VPWR sky130_fd_sc_hd__decap_3
XFILLER_15_122 VGND VGND VPWR VPWR sky130_fd_sc_hd__decap_3
XFILLER_15_177 VGND VGND VPWR VPWR sky130_fd_sc_hd__decap_3
X_2083_ fanout94/X _2083_/D _1756_/A VGND VGND VPWR VPWR _2083_/Q sky130_fd_sc_hd__dfrtp_2
X_1103_ _1104_/A _1160_/B VGND VGND VPWR VPWR _1267_/A sky130_fd_sc_hd__or2_2
X_1034_ _2025_/Q _1149_/A VGND VGND VPWR VPWR _1034_/X sky130_fd_sc_hd__and2b_2
X_1936_ _2036_/CLK _1936_/D VGND VGND VPWR VPWR _1936_/Q sky130_fd_sc_hd__dfxtp_2
X_1867_ clkload6/A _1867_/D VGND VGND VPWR VPWR _1867_/Q sky130_fd_sc_hd__dfxtp_2
XFILLER_21_169 VGND VGND VPWR VPWR sky130_fd_sc_hd__decap_3
X_1798_ _1806_/A _2065_/Q VGND VGND VPWR VPWR _1798_/X sky130_fd_sc_hd__or2_2
XFILLER_29_236 VGND VGND VPWR VPWR sky130_fd_sc_hd__decap_3
XFILLER_29_225 VGND VGND VPWR VPWR sky130_fd_sc_hd__decap_3
XFILLER_29_203 VGND VGND VPWR VPWR sky130_fd_sc_hd__decap_3
XFILLER_52_250 VGND VGND VPWR VPWR sky130_fd_sc_hd__fill_2
XFILLER_44_239 VGND VGND VPWR VPWR sky130_fd_sc_hd__decap_3
XFILLER_16_88 VGND VGND VPWR VPWR sky130_fd_sc_hd__fill_1
XTAP_TAPCELL_ROW_7_151 VGND VPWR sky130_fd_sc_hd__tapvpwrvgnd_1
XFILLER_35_228 VGND VGND VPWR VPWR sky130_fd_sc_hd__fill_1
X_1721_ _2028_/Q _1724_/B _1720_/Y _1723_/C1 VGND VGND VPWR VPWR _2028_/D sky130_fd_sc_hd__o211a_2
XTAP_TAPCELL_ROW_13_186 VGND VPWR sky130_fd_sc_hd__tapvpwrvgnd_1
Xhold129 _2011_/Q VGND VGND VPWR VPWR hold129/X sky130_fd_sc_hd__dlygate4sd3_1
Xhold118 _1945_/Q VGND VGND VPWR VPWR hold118/X sky130_fd_sc_hd__dlygate4sd3_1
X_1652_ _1994_/Q _1646_/X _1651_/Y VGND VGND VPWR VPWR _1994_/D sky130_fd_sc_hd__a21o_2
X_1583_ _1629_/B _1604_/B VGND VGND VPWR VPWR _1587_/S sky130_fd_sc_hd__nor2_2
XFILLER_7_151 VGND VGND VPWR VPWR sky130_fd_sc_hd__decap_3
X_2135_ _2135_/A VGND VGND VPWR VPWR uo_out[5] sky130_fd_sc_hd__buf_2
X_1017_ _1869_/Q _0999_/X _1337_/A1 _1881_/Q VGND VGND VPWR VPWR _1017_/X sky130_fd_sc_hd__a22o_2
X_2066_ _2068_/CLK _2066_/D VGND VGND VPWR VPWR _2066_/Q sky130_fd_sc_hd__dfxtp_2
X_1919_ clkload3/A _1919_/D VGND VGND VPWR VPWR _1919_/Q sky130_fd_sc_hd__dfxtp_2
XFILLER_27_98 VGND VGND VPWR VPWR sky130_fd_sc_hd__decap_3
XFILLER_43_53 VGND VGND VPWR VPWR sky130_fd_sc_hd__decap_3
XFILLER_40_297 VGND VGND VPWR VPWR sky130_fd_sc_hd__fill_2
XFILLER_40_264 VGND VGND VPWR VPWR sky130_fd_sc_hd__fill_1
XFILLER_40_253 VGND VGND VPWR VPWR sky130_fd_sc_hd__decap_3
XFILLER_40_231 VGND VGND VPWR VPWR sky130_fd_sc_hd__decap_3
XFILLER_4_132 VGND VGND VPWR VPWR sky130_fd_sc_hd__decap_3
XTAP_TAPCELL_ROW_10_167 VGND VPWR sky130_fd_sc_hd__tapvpwrvgnd_1
XFILLER_31_231 VGND VGND VPWR VPWR sky130_fd_sc_hd__fill_1
XFILLER_16_272 VGND VGND VPWR VPWR sky130_fd_sc_hd__fill_1
XTAP_TAPCELL_ROW_18_212 VGND VPWR sky130_fd_sc_hd__tapvpwrvgnd_1
X_1704_ _2057_/Q _1697_/B _1703_/X _1779_/B1 VGND VGND VPWR VPWR _2020_/D sky130_fd_sc_hd__o211a_2
X_1566_ _1679_/A _1570_/B VGND VGND VPWR VPWR _1566_/Y sky130_fd_sc_hd__nor2_2
X_1635_ _1489_/Y _1505_/X _1640_/B _1634_/X VGND VGND VPWR VPWR _1985_/D sky130_fd_sc_hd__a31o_2
X_1497_ _1497_/A VGND VGND VPWR VPWR _1598_/B sky130_fd_sc_hd__inv_2
XTAP_TAPCELL_ROW_49_381 VGND VPWR sky130_fd_sc_hd__tapvpwrvgnd_1
X_2049_ _2068_/CLK _2049_/D VGND VGND VPWR VPWR _2049_/Q sky130_fd_sc_hd__dfxtp_2
XFILLER_14_209 VGND VGND VPWR VPWR sky130_fd_sc_hd__fill_2
Xfanout68 _1910_/Q VGND VGND VPWR VPWR _1003_/B sky130_fd_sc_hd__clkdlybuf4s25_1
Xfanout35 _1330_/B VGND VGND VPWR VPWR _1325_/A sky130_fd_sc_hd__clkdlybuf4s25_1
XTAP_TAPCELL_ROW_32_292 VGND VPWR sky130_fd_sc_hd__tapvpwrvgnd_1
Xfanout46 _0996_/Y VGND VGND VPWR VPWR _1371_/A1 sky130_fd_sc_hd__clkdlybuf4s25_1
Xfanout24 _1390_/B VGND VGND VPWR VPWR _1402_/B sky130_fd_sc_hd__clkdlybuf4s25_1
XTAP_TAPCELL_ROW_24_248 VGND VPWR sky130_fd_sc_hd__tapvpwrvgnd_1
Xfanout13 _1714_/B VGND VGND VPWR VPWR _1724_/B sky130_fd_sc_hd__clkdlybuf4s25_1
Xfanout57 _2062_/Q VGND VGND VPWR VPWR _1792_/B sky130_fd_sc_hd__clkdlybuf4s25_1
Xfanout79 _1811_/B1 VGND VGND VPWR VPWR _1809_/B1 sky130_fd_sc_hd__clkdlybuf4s25_1
XFILLER_22_242 VGND VGND VPWR VPWR sky130_fd_sc_hd__fill_2
XFILLER_13_78 VGND VGND VPWR VPWR sky130_fd_sc_hd__fill_1
XFILLER_49_139 VGND VGND VPWR VPWR sky130_fd_sc_hd__fill_2
XFILLER_9_213 VGND VGND VPWR VPWR sky130_fd_sc_hd__decap_3
XFILLER_9_279 VGND VGND VPWR VPWR sky130_fd_sc_hd__fill_1
X_1420_ _1902_/Q _1846_/D _1419_/Y VGND VGND VPWR VPWR _1902_/D sky130_fd_sc_hd__o21a_2
X_1351_ _1872_/Q _1352_/B _1350_/Y _1403_/C1 VGND VGND VPWR VPWR _1872_/D sky130_fd_sc_hd__o211a_2
XFILLER_36_323 VGND VGND VPWR VPWR sky130_fd_sc_hd__fill_1
X_1282_ _2013_/Q _1299_/A VGND VGND VPWR VPWR _1283_/B sky130_fd_sc_hd__xor2_2
XTAP_TAPCELL_ROW_21_229 VGND VPWR sky130_fd_sc_hd__tapvpwrvgnd_1
X_0997_ _1028_/A _1449_/A VGND VGND VPWR VPWR _1457_/A sky130_fd_sc_hd__or2_2
X_1618_ _1979_/Q _1772_/B _1618_/S VGND VGND VPWR VPWR _1979_/D sky130_fd_sc_hd__mux2_1
X_1549_ _1679_/A _1553_/B VGND VGND VPWR VPWR _1549_/Y sky130_fd_sc_hd__nor2_2
XFILLER_5_90 VGND VGND VPWR VPWR sky130_fd_sc_hd__fill_1
XFILLER_27_323 VGND VGND VPWR VPWR sky130_fd_sc_hd__fill_1
XTAP_TAPCELL_ROW_52_398 VGND VPWR sky130_fd_sc_hd__tapvpwrvgnd_1
XFILLER_24_99 VGND VGND VPWR VPWR sky130_fd_sc_hd__fill_1
XFILLER_24_66 VGND VGND VPWR VPWR sky130_fd_sc_hd__fill_1
XFILLER_10_234 VGND VGND VPWR VPWR sky130_fd_sc_hd__fill_2
XFILLER_10_245 VGND VGND VPWR VPWR sky130_fd_sc_hd__decap_3
XFILLER_10_256 VGND VGND VPWR VPWR sky130_fd_sc_hd__decap_3
XFILLER_10_289 VGND VGND VPWR VPWR sky130_fd_sc_hd__fill_1
XFILLER_37_109 VGND VGND VPWR VPWR sky130_fd_sc_hd__decap_3
XFILLER_18_323 VGND VGND VPWR VPWR sky130_fd_sc_hd__fill_1
X_0920_ _1796_/B VGND VGND VPWR VPWR _1640_/C sky130_fd_sc_hd__inv_2
X_1334_ _1834_/A _1384_/A _1342_/B _1333_/Y VGND VGND VPWR VPWR _1864_/D sky130_fd_sc_hd__a31oi_2
X_1403_ _1897_/Q _1402_/B _1402_/Y _1403_/C1 VGND VGND VPWR VPWR _1897_/D sky130_fd_sc_hd__o211a_2
XFILLER_5_293 VGND VGND VPWR VPWR sky130_fd_sc_hd__decap_3
X_1265_ _1265_/A _1265_/B _1265_/C VGND VGND VPWR VPWR _1265_/X sky130_fd_sc_hd__and3_2
XPHY_EDGE_ROW_18_Right_18 VGND VGND VPWR VPWR sky130_fd_sc_hd__decap_3
Xinput3 ui_in[0] VGND VGND VPWR VPWR input3/X sky130_fd_sc_hd__clkdlybuf4s25_1
XPHY_EDGE_ROW_27_Right_27 VGND VGND VPWR VPWR sky130_fd_sc_hd__decap_3
X_1196_ _2022_/Q _1327_/A VGND VGND VPWR VPWR _1196_/X sky130_fd_sc_hd__and2_2
XPHY_EDGE_ROW_36_Right_36 VGND VGND VPWR VPWR sky130_fd_sc_hd__decap_3
XFILLER_10_35 VGND VGND VPWR VPWR sky130_fd_sc_hd__fill_1
XPHY_EDGE_ROW_45_Right_45 VGND VGND VPWR VPWR sky130_fd_sc_hd__decap_3
XFILLER_42_112 VGND VGND VPWR VPWR sky130_fd_sc_hd__fill_1
XTAP_TAPCELL_ROW_40_335 VGND VPWR sky130_fd_sc_hd__tapvpwrvgnd_1
XFILLER_15_304 VGND VGND VPWR VPWR sky130_fd_sc_hd__fill_2
XFILLER_2_285 VGND VGND VPWR VPWR sky130_fd_sc_hd__decap_3
X_1050_ _2029_/Q _1158_/A VGND VGND VPWR VPWR _1050_/X sky130_fd_sc_hd__and2b_2
X_1883_ clkload6/A _1883_/D VGND VGND VPWR VPWR _1883_/Q sky130_fd_sc_hd__dfxtp_2
X_1952_ _2064_/CLK _1952_/D VGND VGND VPWR VPWR _1952_/Q sky130_fd_sc_hd__dfxtp_2
X_1317_ _1858_/Q _1325_/A _1316_/Y _1403_/C1 VGND VGND VPWR VPWR _1858_/D sky130_fd_sc_hd__o211a_2
XFILLER_2_91 VGND VGND VPWR VPWR sky130_fd_sc_hd__decap_3
X_1248_ _1102_/A _1172_/B _1240_/A VGND VGND VPWR VPWR _1249_/B sky130_fd_sc_hd__a21bo_2
X_1179_ _1098_/X _1180_/B _0991_/Y VGND VGND VPWR VPWR _1179_/X sky130_fd_sc_hd__o21a_2
XFILLER_47_259 VGND VGND VPWR VPWR sky130_fd_sc_hd__decap_3
XFILLER_46_97 VGND VGND VPWR VPWR sky130_fd_sc_hd__fill_2
XFILLER_15_156 VGND VGND VPWR VPWR sky130_fd_sc_hd__decap_3
XFILLER_15_189 VGND VGND VPWR VPWR sky130_fd_sc_hd__fill_2
X_2082_ fanout94/X _2082_/D _1756_/A VGND VGND VPWR VPWR _2082_/Q sky130_fd_sc_hd__dfrtp_2
X_1102_ _1102_/A _1160_/B VGND VGND VPWR VPWR _1163_/A sky130_fd_sc_hd__xor2_2
X_1033_ _2024_/Q _1181_/A VGND VGND VPWR VPWR _1275_/A sky130_fd_sc_hd__nand2_2
X_1935_ _2035_/CLK _1935_/D VGND VGND VPWR VPWR _1935_/Q sky130_fd_sc_hd__dfxtp_2
X_1866_ _1899_/CLK _1866_/D VGND VGND VPWR VPWR _1866_/Q sky130_fd_sc_hd__dfxtp_2
X_1797_ _1807_/A1 _1794_/B _1809_/B1 _1796_/X VGND VGND VPWR VPWR _2064_/D sky130_fd_sc_hd__o211a_2
XPHY_EDGE_ROW_0_Right_0 VGND VGND VPWR VPWR sky130_fd_sc_hd__decap_3
XFILLER_8_108 VGND VGND VPWR VPWR sky130_fd_sc_hd__fill_2
XTAP_TAPCELL_ROW_7_152 VGND VPWR sky130_fd_sc_hd__tapvpwrvgnd_1
X_1651_ _1681_/A _1653_/B VGND VGND VPWR VPWR _1651_/Y sky130_fd_sc_hd__nor2_2
X_1720_ _2053_/Q _1724_/B VGND VGND VPWR VPWR _1720_/Y sky130_fd_sc_hd__nand2b_2
XFILLER_7_174 VGND VGND VPWR VPWR sky130_fd_sc_hd__decap_3
XFILLER_11_181 VGND VGND VPWR VPWR sky130_fd_sc_hd__fill_2
XTAP_TAPCELL_ROW_13_187 VGND VPWR sky130_fd_sc_hd__tapvpwrvgnd_1
Xhold119 _2137_/A VGND VGND VPWR VPWR hold119/X sky130_fd_sc_hd__dlygate4sd3_1
X_1582_ _1598_/B _1598_/A VGND VGND VPWR VPWR _1604_/B sky130_fd_sc_hd__or2_2
XFILLER_7_196 VGND VGND VPWR VPWR sky130_fd_sc_hd__fill_1
X_2134_ _2134_/A VGND VGND VPWR VPWR uo_out[4] sky130_fd_sc_hd__buf_2
X_2065_ _2065_/CLK _2065_/D VGND VGND VPWR VPWR _2065_/Q sky130_fd_sc_hd__dfxtp_2
X_1016_ _2030_/Q _1159_/A VGND VGND VPWR VPWR _1222_/B sky130_fd_sc_hd__and2_2
X_1849_ _0931_/Y _1848_/S _1840_/B _1422_/X VGND VGND VPWR VPWR _2115_/D sky130_fd_sc_hd__a2bb2o_2
X_1918_ _1963_/CLK _1918_/D VGND VGND VPWR VPWR _1918_/Q sky130_fd_sc_hd__dfxtp_2
XTAP_TAPCELL_ROW_4_133 VGND VPWR sky130_fd_sc_hd__tapvpwrvgnd_1
XFILLER_40_210 VGND VGND VPWR VPWR sky130_fd_sc_hd__decap_3
XFILLER_25_240 VGND VGND VPWR VPWR sky130_fd_sc_hd__decap_3
XFILLER_40_221 VGND VGND VPWR VPWR sky130_fd_sc_hd__decap_3
Xclkbuf_leaf_20_clk clkbuf_2_2__f_clk/X VGND VGND VPWR VPWR _2068_/CLK sky130_fd_sc_hd__clkbuf_8
XFILLER_4_155 VGND VGND VPWR VPWR sky130_fd_sc_hd__decap_3
XTAP_TAPCELL_ROW_10_168 VGND VPWR sky130_fd_sc_hd__tapvpwrvgnd_1
XFILLER_48_321 VGND VGND VPWR VPWR sky130_fd_sc_hd__decap_3
XTAP_TAPCELL_ROW_18_213 VGND VPWR sky130_fd_sc_hd__tapvpwrvgnd_1
XFILLER_16_251 VGND VGND VPWR VPWR sky130_fd_sc_hd__fill_1
Xclkbuf_leaf_11_clk clkbuf_leaf_3_clk/A VGND VGND VPWR VPWR _2114_/CLK sky130_fd_sc_hd__clkbuf_8
XFILLER_31_287 VGND VGND VPWR VPWR sky130_fd_sc_hd__decap_3
X_1634_ _1985_/Q _1638_/B VGND VGND VPWR VPWR _1634_/X sky130_fd_sc_hd__and2_2
X_1703_ _2020_/Q _1707_/B VGND VGND VPWR VPWR _1703_/X sky130_fd_sc_hd__or2_2
X_1565_ hold126/X _1563_/X _1564_/Y VGND VGND VPWR VPWR _1944_/D sky130_fd_sc_hd__a21o_2
X_1496_ _1631_/A _1496_/B VGND VGND VPWR VPWR _1497_/A sky130_fd_sc_hd__nor2_2
XTAP_TAPCELL_ROW_49_382 VGND VPWR sky130_fd_sc_hd__tapvpwrvgnd_1
X_2117_ clkload8/A _2117_/D VGND VGND VPWR VPWR _2117_/Q sky130_fd_sc_hd__dfxtp_2
X_2048_ clkload2/A _2048_/D VGND VGND VPWR VPWR _2048_/Q sky130_fd_sc_hd__dfxtp_2
Xfanout69 _1909_/Q VGND VGND VPWR VPWR _1083_/S0 sky130_fd_sc_hd__clkdlybuf4s25_1
Xfanout25 _1390_/B VGND VGND VPWR VPWR _1406_/B sky130_fd_sc_hd__clkdlybuf4s25_1
Xfanout36 _0998_/Y VGND VGND VPWR VPWR _1330_/B sky130_fd_sc_hd__clkdlybuf4s25_1
XFILLER_13_57 VGND VGND VPWR VPWR sky130_fd_sc_hd__fill_1
Xfanout58 _2061_/Q VGND VGND VPWR VPWR _1790_/B sky130_fd_sc_hd__clkdlybuf4s25_1
Xfanout47 _0993_/A VGND VGND VPWR VPWR _1266_/B1 sky130_fd_sc_hd__clkdlybuf4s25_1
Xfanout14 _1178_/X VGND VGND VPWR VPWR _1180_/C sky130_fd_sc_hd__clkdlybuf4s25_1
XFILLER_1_158 VGND VGND VPWR VPWR sky130_fd_sc_hd__fill_2
XFILLER_38_43 VGND VGND VPWR VPWR sky130_fd_sc_hd__fill_1
XFILLER_1_169 VGND VGND VPWR VPWR sky130_fd_sc_hd__decap_3
X_1350_ _1400_/A _1352_/B VGND VGND VPWR VPWR _1350_/Y sky130_fd_sc_hd__nand2_2
X_1281_ _2012_/Q _1296_/A VGND VGND VPWR VPWR _1283_/A sky130_fd_sc_hd__or2_2
XFILLER_36_302 VGND VGND VPWR VPWR sky130_fd_sc_hd__decap_3
Xclkbuf_leaf_0_clk clkbuf_leaf_2_clk/A VGND VGND VPWR VPWR _2077_/CLK sky130_fd_sc_hd__clkbuf_8
X_0996_ _1028_/A _1449_/A VGND VGND VPWR VPWR _0996_/Y sky130_fd_sc_hd__nor2_2
X_1617_ hold164/X _2051_/Q _1618_/S VGND VGND VPWR VPWR _1978_/D sky130_fd_sc_hd__mux2_1
X_1548_ hold128/X _1546_/X _1547_/Y VGND VGND VPWR VPWR _1936_/D sky130_fd_sc_hd__a21o_2
X_1479_ _2074_/Q _2073_/Q _1484_/B _1478_/X VGND VGND VPWR VPWR _1480_/B sky130_fd_sc_hd__or4b_2
XTAP_TAPCELL_ROW_52_399 VGND VPWR sky130_fd_sc_hd__tapvpwrvgnd_1
XFILLER_10_268 VGND VGND VPWR VPWR sky130_fd_sc_hd__decap_3
XFILLER_6_3 VGND VGND VPWR VPWR sky130_fd_sc_hd__fill_1
XFILLER_45_143 VGND VGND VPWR VPWR sky130_fd_sc_hd__fill_1
X_1402_ _1402_/A _1402_/B VGND VGND VPWR VPWR _1402_/Y sky130_fd_sc_hd__nand2_2
XFILLER_5_250 VGND VGND VPWR VPWR sky130_fd_sc_hd__decap_3
Xinput4 ui_in[1] VGND VGND VPWR VPWR input4/X sky130_fd_sc_hd__clkdlybuf4s25_1
XFILLER_39_3 VGND VGND VPWR VPWR sky130_fd_sc_hd__decap_3
X_1333_ _1864_/Q _1342_/B _1407_/C1 VGND VGND VPWR VPWR _1333_/Y sky130_fd_sc_hd__o21ai_2
X_1264_ _1264_/A _1264_/B _1264_/C VGND VGND VPWR VPWR _1264_/X sky130_fd_sc_hd__or3_2
XFILLER_36_187 VGND VGND VPWR VPWR sky130_fd_sc_hd__fill_1
Xclkbuf_2_1__f_clk clkbuf_0_clk/X VGND VGND VPWR VPWR clkbuf_leaf_9_clk/A sky130_fd_sc_hd__clkbuf_16
XTAP_TAPCELL_ROW_34_300 VGND VPWR sky130_fd_sc_hd__tapvpwrvgnd_1
X_1195_ _2022_/Q _1327_/A _1189_/X _1188_/Y VGND VGND VPWR VPWR _1195_/X sky130_fd_sc_hd__a2bb2o_2
X_0979_ a_selb1[1] VGND VGND VPWR VPWR a_sel1[1] sky130_fd_sc_hd__inv_2
XFILLER_27_110 VGND VGND VPWR VPWR sky130_fd_sc_hd__fill_2
XTAP_TAPCELL_ROW_40_336 VGND VPWR sky130_fd_sc_hd__tapvpwrvgnd_1
XFILLER_35_77 VGND VGND VPWR VPWR sky130_fd_sc_hd__decap_3
XFILLER_35_66 VGND VGND VPWR VPWR sky130_fd_sc_hd__decap_3
XFILLER_35_55 VGND VGND VPWR VPWR sky130_fd_sc_hd__fill_1
XFILLER_2_242 VGND VGND VPWR VPWR sky130_fd_sc_hd__decap_3
XFILLER_33_113 VGND VGND VPWR VPWR sky130_fd_sc_hd__decap_3
XFILLER_18_110 VGND VGND VPWR VPWR sky130_fd_sc_hd__decap_3
XFILLER_41_190 VGND VGND VPWR VPWR sky130_fd_sc_hd__fill_1
X_1882_ _1899_/CLK _1882_/D VGND VGND VPWR VPWR _1882_/Q sky130_fd_sc_hd__dfxtp_2
X_1951_ _2065_/CLK _1951_/D VGND VGND VPWR VPWR _1951_/Q sky130_fd_sc_hd__dfxtp_2
X_1316_ _1325_/A _1396_/A VGND VGND VPWR VPWR _1316_/Y sky130_fd_sc_hd__nand2_2
X_1247_ _1264_/B _1244_/Y _1246_/X _1189_/B VGND VGND VPWR VPWR _1247_/X sky130_fd_sc_hd__o22a_2
X_1178_ _1178_/A _1178_/B VGND VGND VPWR VPWR _1178_/X sky130_fd_sc_hd__and2_2
XFILLER_32_190 VGND VGND VPWR VPWR sky130_fd_sc_hd__decap_3
XFILLER_24_168 VGND VGND VPWR VPWR sky130_fd_sc_hd__decap_3
XFILLER_24_113 VGND VGND VPWR VPWR sky130_fd_sc_hd__decap_3
XFILLER_21_57 VGND VGND VPWR VPWR sky130_fd_sc_hd__fill_1
XFILLER_15_113 VGND VGND VPWR VPWR sky130_fd_sc_hd__decap_3
Xmax_cap33 _1064_/A VGND VGND VPWR VPWR _1211_/A1 sky130_fd_sc_hd__clkbuf_2
XFILLER_30_149 VGND VGND VPWR VPWR sky130_fd_sc_hd__fill_1
XFILLER_7_48 VGND VGND VPWR VPWR sky130_fd_sc_hd__decap_3
XFILLER_7_323 VGND VGND VPWR VPWR sky130_fd_sc_hd__fill_1
XFILLER_38_205 VGND VGND VPWR VPWR sky130_fd_sc_hd__decap_3
X_1032_ _1852_/Q _1864_/Q _1876_/Q _1888_/Q _1028_/B _1028_/A VGND VGND VPWR VPWR
+ _1181_/A sky130_fd_sc_hd__mux4_2
XFILLER_23_6 VGND VGND VPWR VPWR sky130_fd_sc_hd__decap_3
X_2081_ fanout94/X _2081_/D _1756_/A VGND VGND VPWR VPWR _2081_/Q sky130_fd_sc_hd__dfrtp_2
X_1101_ _1180_/A _1101_/B VGND VGND VPWR VPWR _1190_/A sky130_fd_sc_hd__and2_2
X_1934_ _2035_/CLK _1934_/D VGND VGND VPWR VPWR _1934_/Q sky130_fd_sc_hd__dfxtp_2
X_1865_ _1899_/CLK _1865_/D VGND VGND VPWR VPWR _1865_/Q sky130_fd_sc_hd__dfxtp_2
X_1796_ _1806_/A _1796_/B VGND VGND VPWR VPWR _1796_/X sky130_fd_sc_hd__or2_2
XFILLER_52_241 VGND VGND VPWR VPWR sky130_fd_sc_hd__decap_3
XFILLER_37_260 VGND VGND VPWR VPWR sky130_fd_sc_hd__fill_1
XFILLER_16_46 VGND VGND VPWR VPWR sky130_fd_sc_hd__fill_1
XFILLER_32_56 VGND VGND VPWR VPWR sky130_fd_sc_hd__decap_3
XFILLER_20_193 VGND VGND VPWR VPWR sky130_fd_sc_hd__decap_3
XFILLER_4_315 VGND VGND VPWR VPWR sky130_fd_sc_hd__decap_3
XFILLER_4_304 VGND VGND VPWR VPWR sky130_fd_sc_hd__decap_3
XTAP_TAPCELL_ROW_7_153 VGND VPWR sky130_fd_sc_hd__tapvpwrvgnd_1
X_1650_ _1993_/Q _1646_/X _1649_/Y VGND VGND VPWR VPWR _1993_/D sky130_fd_sc_hd__a21o_2
X_1581_ _1628_/A _1598_/A VGND VGND VPWR VPWR _1626_/C sky130_fd_sc_hd__nor2_2
XFILLER_21_3 VGND VGND VPWR VPWR sky130_fd_sc_hd__decap_3
X_1015_ _1858_/Q _1137_/A2 _1337_/B2 _1894_/Q _1014_/X VGND VGND VPWR VPWR _1159_/A
+ sky130_fd_sc_hd__a221o_2
XFILLER_26_208 VGND VGND VPWR VPWR sky130_fd_sc_hd__decap_3
X_2064_ _2064_/CLK _2064_/D VGND VGND VPWR VPWR _2064_/Q sky130_fd_sc_hd__dfxtp_2
X_1917_ clkload3/A _1917_/D VGND VGND VPWR VPWR _1917_/Q sky130_fd_sc_hd__dfxtp_2
XPHY_EDGE_ROW_14_Left_67 VGND VGND VPWR VPWR sky130_fd_sc_hd__decap_3
X_1848_ hold135/X _1834_/Y _1848_/S VGND VGND VPWR VPWR _2114_/D sky130_fd_sc_hd__mux2_1
X_1779_ _1809_/A1 _2054_/Q _1779_/B1 _1778_/X VGND VGND VPWR VPWR _2055_/D sky130_fd_sc_hd__o211a_2
XFILLER_8_80 VGND VGND VPWR VPWR sky130_fd_sc_hd__fill_1
XFILLER_8_91 VGND VGND VPWR VPWR sky130_fd_sc_hd__decap_3
XTAP_TAPCELL_ROW_4_134 VGND VPWR sky130_fd_sc_hd__tapvpwrvgnd_1
XTAP_TAPCELL_ROW_10_169 VGND VPWR sky130_fd_sc_hd__tapvpwrvgnd_1
XFILLER_4_38 VGND VGND VPWR VPWR sky130_fd_sc_hd__decap_3
XTAP_TAPCELL_ROW_18_214 VGND VPWR sky130_fd_sc_hd__tapvpwrvgnd_1
XFILLER_31_222 VGND VGND VPWR VPWR sky130_fd_sc_hd__fill_2
XFILLER_31_200 VGND VGND VPWR VPWR sky130_fd_sc_hd__decap_3
X_1564_ _1677_/A _1570_/B VGND VGND VPWR VPWR _1564_/Y sky130_fd_sc_hd__nor2_2
X_1633_ _1489_/Y _1501_/X _1640_/B _1632_/X VGND VGND VPWR VPWR _1984_/D sky130_fd_sc_hd__a31o_2
X_1702_ _2056_/Q _1697_/B _1701_/X _1779_/B1 VGND VGND VPWR VPWR _2019_/D sky130_fd_sc_hd__o211a_2
XFILLER_39_322 VGND VGND VPWR VPWR sky130_fd_sc_hd__fill_2
X_1495_ _1796_/B _1629_/B _1573_/C VGND VGND VPWR VPWR _1514_/B sky130_fd_sc_hd__or3_2
XTAP_TAPCELL_ROW_49_383 VGND VPWR sky130_fd_sc_hd__tapvpwrvgnd_1
X_2116_ clkload8/A _2116_/D VGND VGND VPWR VPWR _2116_/Q sky130_fd_sc_hd__dfxtp_2
Xfanout37 _1441_/A VGND VGND VPWR VPWR _1383_/A sky130_fd_sc_hd__clkdlybuf4s25_1
Xfanout26 _1383_/Y VGND VGND VPWR VPWR _1390_/B sky130_fd_sc_hd__clkdlybuf4s25_1
X_2047_ _2058_/CLK _2047_/D VGND VGND VPWR VPWR _2047_/Q sky130_fd_sc_hd__dfxtp_2
Xfanout15 _1099_/Y VGND VGND VPWR VPWR _1180_/A sky130_fd_sc_hd__clkdlybuf4s25_1
XFILLER_22_200 VGND VGND VPWR VPWR sky130_fd_sc_hd__decap_3
XFILLER_22_299 VGND VGND VPWR VPWR sky130_fd_sc_hd__fill_1
Xfanout48 _1816_/A VGND VGND VPWR VPWR _1809_/A1 sky130_fd_sc_hd__clkdlybuf4s25_1
Xfanout59 _2052_/Q VGND VGND VPWR VPWR _1772_/B sky130_fd_sc_hd__clkdlybuf4s25_1
XFILLER_1_137 VGND VGND VPWR VPWR sky130_fd_sc_hd__fill_2
XFILLER_13_222 VGND VGND VPWR VPWR sky130_fd_sc_hd__fill_2
XFILLER_48_141 VGND VGND VPWR VPWR sky130_fd_sc_hd__fill_1
X_1280_ _2013_/Q _1299_/A VGND VGND VPWR VPWR _1280_/X sky130_fd_sc_hd__and2_2
XTAP_TAPCELL_ROW_46_364 VGND VPWR sky130_fd_sc_hd__tapvpwrvgnd_1
X_0995_ _1449_/A _1383_/A VGND VGND VPWR VPWR _0995_/Y sky130_fd_sc_hd__nor2_2
XFILLER_8_281 VGND VGND VPWR VPWR sky130_fd_sc_hd__decap_3
X_1547_ _1677_/A _1553_/B VGND VGND VPWR VPWR _1547_/Y sky130_fd_sc_hd__nor2_2
X_1616_ hold172/X _1506_/A _1618_/S VGND VGND VPWR VPWR _1977_/D sky130_fd_sc_hd__mux2_1
XFILLER_39_130 VGND VGND VPWR VPWR sky130_fd_sc_hd__fill_2
X_1478_ _2075_/Q _1824_/A _2077_/Q _2076_/Q VGND VGND VPWR VPWR _1478_/X sky130_fd_sc_hd__and4b_2
XPHY_EDGE_ROW_17_Left_70 VGND VGND VPWR VPWR sky130_fd_sc_hd__decap_3
XFILLER_18_303 VGND VGND VPWR VPWR sky130_fd_sc_hd__decap_3
X_1401_ _1896_/Q _1406_/B _1400_/Y _1831_/C VGND VGND VPWR VPWR _1896_/D sky130_fd_sc_hd__o211a_2
XFILLER_5_262 VGND VGND VPWR VPWR sky130_fd_sc_hd__decap_3
XFILLER_5_284 VGND VGND VPWR VPWR sky130_fd_sc_hd__decap_3
Xinput5 ui_in[2] VGND VGND VPWR VPWR input5/X sky130_fd_sc_hd__clkdlybuf4s25_1
X_1332_ _1383_/A _1460_/A VGND VGND VPWR VPWR _1332_/Y sky130_fd_sc_hd__nor2_2
XFILLER_36_144 VGND VGND VPWR VPWR sky130_fd_sc_hd__fill_2
X_1263_ _1265_/C _1263_/B VGND VGND VPWR VPWR _1264_/C sky130_fd_sc_hd__nor2_2
X_1194_ _1192_/X _1193_/X _1279_/A1 _1191_/X VGND VGND VPWR VPWR _1327_/A sky130_fd_sc_hd__a2bb2o_2
XFILLER_51_169 VGND VGND VPWR VPWR sky130_fd_sc_hd__decap_3
XFILLER_51_103 VGND VGND VPWR VPWR sky130_fd_sc_hd__fill_2
XFILLER_36_166 VGND VGND VPWR VPWR sky130_fd_sc_hd__fill_2
XFILLER_36_155 VGND VGND VPWR VPWR sky130_fd_sc_hd__decap_3
XTAP_TAPCELL_ROW_34_301 VGND VPWR sky130_fd_sc_hd__tapvpwrvgnd_1
XFILLER_24_317 VGND VGND VPWR VPWR sky130_fd_sc_hd__decap_3
X_0978_ _2043_/Q _2041_/Q _2042_/Q VGND VGND VPWR VPWR a_selb1[1] sky130_fd_sc_hd__or3b_2
XFILLER_27_133 VGND VGND VPWR VPWR sky130_fd_sc_hd__fill_2
XFILLER_51_55 VGND VGND VPWR VPWR sky130_fd_sc_hd__fill_1
XFILLER_50_191 VGND VGND VPWR VPWR sky130_fd_sc_hd__decap_3
XPHY_EDGE_ROW_2_Left_55 VGND VGND VPWR VPWR sky130_fd_sc_hd__decap_3
XFILLER_2_221 VGND VGND VPWR VPWR sky130_fd_sc_hd__decap_3
XFILLER_33_169 VGND VGND VPWR VPWR sky130_fd_sc_hd__decap_3
X_1950_ _1963_/CLK _1950_/D VGND VGND VPWR VPWR _1950_/Q sky130_fd_sc_hd__dfxtp_2
X_1881_ clkload7/A _1881_/D VGND VGND VPWR VPWR _1881_/Q sky130_fd_sc_hd__dfxtp_2
X_1315_ _1315_/A _1327_/B _1327_/C VGND VGND VPWR VPWR _1396_/A sky130_fd_sc_hd__or3_2
XFILLER_2_82 VGND VGND VPWR VPWR sky130_fd_sc_hd__fill_2
X_1246_ _1227_/B _1245_/X _1266_/B1 VGND VGND VPWR VPWR _1246_/X sky130_fd_sc_hd__o21a_2
X_1177_ _1190_/B _1190_/C _1190_/D _1190_/A VGND VGND VPWR VPWR _1177_/Y sky130_fd_sc_hd__o31ai_2
XPHY_EDGE_ROW_44_Left_97 VGND VGND VPWR VPWR sky130_fd_sc_hd__decap_3
XFILLER_20_320 VGND VGND VPWR VPWR sky130_fd_sc_hd__decap_3
Xmax_cap12 _1257_/B VGND VGND VPWR VPWR _1264_/B sky130_fd_sc_hd__clkbuf_2
XFILLER_46_44 VGND VGND VPWR VPWR sky130_fd_sc_hd__fill_1
XFILLER_30_128 VGND VGND VPWR VPWR sky130_fd_sc_hd__decap_3
XFILLER_30_139 VGND VGND VPWR VPWR sky130_fd_sc_hd__fill_1
XFILLER_11_80 VGND VGND VPWR VPWR sky130_fd_sc_hd__fill_1
X_1031_ _1853_/Q _1865_/Q _1877_/Q _1889_/Q _1028_/B _1028_/A VGND VGND VPWR VPWR
+ _1149_/A sky130_fd_sc_hd__mux4_2
X_2080_ fanout94/X _2080_/D _1756_/A VGND VGND VPWR VPWR _2080_/Q sky130_fd_sc_hd__dfrtp_2
X_1100_ _1100_/A _1172_/B VGND VGND VPWR VPWR _1101_/B sky130_fd_sc_hd__or2_2
X_1933_ clkload3/A _1933_/D VGND VGND VPWR VPWR _1933_/Q sky130_fd_sc_hd__dfxtp_2
XFILLER_14_180 VGND VGND VPWR VPWR sky130_fd_sc_hd__decap_3
X_1864_ _1899_/CLK _1864_/D VGND VGND VPWR VPWR _1864_/Q sky130_fd_sc_hd__dfxtp_2
X_1795_ _1807_/A1 _1792_/B _1809_/B1 _1794_/X VGND VGND VPWR VPWR _2063_/D sky130_fd_sc_hd__o211a_2
XFILLER_29_239 VGND VGND VPWR VPWR sky130_fd_sc_hd__decap_3
XFILLER_29_206 VGND VGND VPWR VPWR sky130_fd_sc_hd__fill_1
XFILLER_52_253 VGND VGND VPWR VPWR sky130_fd_sc_hd__decap_3
XFILLER_52_220 VGND VGND VPWR VPWR sky130_fd_sc_hd__fill_1
X_1229_ _1229_/A _1229_/B VGND VGND VPWR VPWR _1229_/X sky130_fd_sc_hd__or2_2
XFILLER_32_46 VGND VGND VPWR VPWR sky130_fd_sc_hd__decap_3
XFILLER_12_128 VGND VGND VPWR VPWR sky130_fd_sc_hd__decap_3
XTAP_TAPCELL_ROW_7_154 VGND VPWR sky130_fd_sc_hd__tapvpwrvgnd_1
XFILLER_43_253 VGND VGND VPWR VPWR sky130_fd_sc_hd__decap_3
X_1580_ _1626_/A _1497_/A _1515_/X _1579_/X VGND VGND VPWR VPWR _1951_/D sky130_fd_sc_hd__a31o_2
XFILLER_7_110 VGND VGND VPWR VPWR sky130_fd_sc_hd__fill_2
XFILLER_7_154 VGND VGND VPWR VPWR sky130_fd_sc_hd__decap_3
XFILLER_11_172 VGND VGND VPWR VPWR sky130_fd_sc_hd__fill_1
XFILLER_14_3 VGND VGND VPWR VPWR sky130_fd_sc_hd__fill_1
XFILLER_34_231 VGND VGND VPWR VPWR sky130_fd_sc_hd__decap_3
X_1014_ _1870_/Q _1138_/A2 _1337_/A1 _1882_/Q VGND VGND VPWR VPWR _1014_/X sky130_fd_sc_hd__a22o_2
X_2063_ _2064_/CLK _2063_/D VGND VGND VPWR VPWR _2063_/Q sky130_fd_sc_hd__dfxtp_2
X_1847_ hold175/X _1832_/X _1848_/S VGND VGND VPWR VPWR _2113_/D sky130_fd_sc_hd__mux2_1
X_1916_ _2001_/CLK _1916_/D VGND VGND VPWR VPWR _1916_/Q sky130_fd_sc_hd__dfxtp_2
X_1778_ _1808_/A _2055_/Q VGND VGND VPWR VPWR _1778_/X sky130_fd_sc_hd__or2_2
XFILLER_27_57 VGND VGND VPWR VPWR sky130_fd_sc_hd__fill_1
XFILLER_27_46 VGND VGND VPWR VPWR sky130_fd_sc_hd__fill_2
XTAP_TAPCELL_ROW_4_135 VGND VPWR sky130_fd_sc_hd__tapvpwrvgnd_1
XFILLER_40_256 VGND VGND VPWR VPWR sky130_fd_sc_hd__fill_1
XFILLER_25_220 VGND VGND VPWR VPWR sky130_fd_sc_hd__decap_3
XPHY_EDGE_ROW_31_Left_84 VGND VGND VPWR VPWR sky130_fd_sc_hd__decap_3
XFILLER_16_242 VGND VGND VPWR VPWR sky130_fd_sc_hd__fill_2
XFILLER_16_253 VGND VGND VPWR VPWR sky130_fd_sc_hd__decap_3
XTAP_TAPCELL_ROW_18_215 VGND VPWR sky130_fd_sc_hd__tapvpwrvgnd_1
X_1701_ _2019_/Q _1707_/B VGND VGND VPWR VPWR _1701_/X sky130_fd_sc_hd__or2_2
X_1563_ _1676_/A _1570_/B VGND VGND VPWR VPWR _1563_/X sky130_fd_sc_hd__or2_2
X_1632_ _1984_/Q _1638_/B VGND VGND VPWR VPWR _1632_/X sky130_fd_sc_hd__and2_2
X_1494_ _1628_/A _1496_/B VGND VGND VPWR VPWR _1573_/C sky130_fd_sc_hd__or2_2
X_2115_ _2115_/CLK _2115_/D VGND VGND VPWR VPWR _2115_/Q sky130_fd_sc_hd__dfxtp_2
XTAP_TAPCELL_ROW_49_384 VGND VPWR sky130_fd_sc_hd__tapvpwrvgnd_1
Xfanout27 _1365_/B VGND VGND VPWR VPWR _1377_/B sky130_fd_sc_hd__clkdlybuf4s25_1
X_2046_ _2058_/CLK _2046_/D VGND VGND VPWR VPWR _2046_/Q sky130_fd_sc_hd__dfxtp_2
Xfanout16 _1743_/X VGND VGND VPWR VPWR _1764_/B sky130_fd_sc_hd__clkdlybuf4s25_1
Xfanout49 _1816_/A VGND VGND VPWR VPWR _1807_/A1 sky130_fd_sc_hd__clkdlybuf4s25_1
XFILLER_22_212 VGND VGND VPWR VPWR sky130_fd_sc_hd__decap_3
XTAP_TAPCELL_ROW_23_240 VGND VPWR sky130_fd_sc_hd__tapvpwrvgnd_1
XFILLER_9_216 VGND VGND VPWR VPWR sky130_fd_sc_hd__decap_3
XFILLER_13_256 VGND VGND VPWR VPWR sky130_fd_sc_hd__decap_3
XFILLER_0_160 VGND VGND VPWR VPWR sky130_fd_sc_hd__decap_3
XFILLER_0_182 VGND VGND VPWR VPWR sky130_fd_sc_hd__decap_3
XTAP_TAPCELL_ROW_46_365 VGND VPWR sky130_fd_sc_hd__tapvpwrvgnd_1
X_0994_ _1383_/A VGND VGND VPWR VPWR _0994_/Y sky130_fd_sc_hd__inv_2
X_1546_ _1676_/A _1553_/B VGND VGND VPWR VPWR _1546_/X sky130_fd_sc_hd__or2_2
XFILLER_5_60 VGND VGND VPWR VPWR sky130_fd_sc_hd__fill_1
X_1477_ _2071_/Q _1743_/C _2070_/Q _2069_/Q VGND VGND VPWR VPWR _1628_/A sky130_fd_sc_hd__or4b_2
X_1615_ hold132/X _1521_/A _1618_/S VGND VGND VPWR VPWR _1976_/D sky130_fd_sc_hd__mux2_1
XFILLER_39_186 VGND VGND VPWR VPWR sky130_fd_sc_hd__decap_3
X_2029_ _2040_/CLK _2029_/D VGND VGND VPWR VPWR _2029_/Q sky130_fd_sc_hd__dfxtp_2
XFILLER_10_248 VGND VGND VPWR VPWR sky130_fd_sc_hd__decap_3
XFILLER_10_259 VGND VGND VPWR VPWR sky130_fd_sc_hd__decap_3
XTAP_TAPCELL_ROW_20_221 VGND VPWR sky130_fd_sc_hd__tapvpwrvgnd_1
XFILLER_6_219 VGND VGND VPWR VPWR sky130_fd_sc_hd__decap_3
XFILLER_49_77 VGND VGND VPWR VPWR sky130_fd_sc_hd__fill_1
XFILLER_45_101 VGND VGND VPWR VPWR sky130_fd_sc_hd__fill_1
X_1331_ _1383_/A _1457_/A _1187_/Y _1330_/X _1389_/C1 VGND VGND VPWR VPWR _1863_/D
+ sky130_fd_sc_hd__o311a_2
X_1400_ _1400_/A _1406_/B VGND VGND VPWR VPWR _1400_/Y sky130_fd_sc_hd__nand2_2
Xinput6 ui_in[3] VGND VGND VPWR VPWR input6/X sky130_fd_sc_hd__clkdlybuf4s25_1
X_1262_ _1257_/X _1259_/X _1261_/X _1279_/A1 VGND VGND VPWR VPWR _1302_/A sky130_fd_sc_hd__a22o_2
X_1193_ _1211_/A1 _1100_/A _1077_/X _0991_/Y VGND VGND VPWR VPWR _1193_/X sky130_fd_sc_hd__a31o_2
XTAP_TAPCELL_ROW_34_302 VGND VPWR sky130_fd_sc_hd__tapvpwrvgnd_1
X_0977_ a_selb1[0] VGND VGND VPWR VPWR a_sel1[0] sky130_fd_sc_hd__inv_2
X_1529_ _1796_/B _1536_/B VGND VGND VPWR VPWR _1529_/X sky130_fd_sc_hd__or2_2
XFILLER_27_101 VGND VGND VPWR VPWR sky130_fd_sc_hd__decap_3
XFILLER_35_57 VGND VGND VPWR VPWR sky130_fd_sc_hd__decap_3
XFILLER_27_167 VGND VGND VPWR VPWR sky130_fd_sc_hd__fill_1
XPHY_EDGE_ROW_14_Right_14 VGND VGND VPWR VPWR sky130_fd_sc_hd__decap_3
XPHY_EDGE_ROW_23_Right_23 VGND VGND VPWR VPWR sky130_fd_sc_hd__decap_3
XFILLER_2_288 VGND VGND VPWR VPWR sky130_fd_sc_hd__fill_1
XFILLER_2_200 VGND VGND VPWR VPWR sky130_fd_sc_hd__decap_3
XFILLER_33_137 VGND VGND VPWR VPWR sky130_fd_sc_hd__decap_3
XPHY_EDGE_ROW_32_Right_32 VGND VGND VPWR VPWR sky130_fd_sc_hd__decap_3
X_1880_ _1899_/CLK _1880_/D VGND VGND VPWR VPWR _1880_/Q sky130_fd_sc_hd__dfxtp_2
XFILLER_18_189 VGND VGND VPWR VPWR sky130_fd_sc_hd__decap_3
XFILLER_44_3 VGND VGND VPWR VPWR sky130_fd_sc_hd__fill_1
XPHY_EDGE_ROW_41_Right_41 VGND VGND VPWR VPWR sky130_fd_sc_hd__decap_3
X_1314_ _1857_/Q _1325_/A _1313_/Y _1395_/C1 VGND VGND VPWR VPWR _1857_/D sky130_fd_sc_hd__o211a_2
XPHY_EDGE_ROW_50_Right_50 VGND VGND VPWR VPWR sky130_fd_sc_hd__decap_3
XFILLER_49_292 VGND VGND VPWR VPWR sky130_fd_sc_hd__fill_2
XFILLER_49_281 VGND VGND VPWR VPWR sky130_fd_sc_hd__decap_3
X_1245_ _1245_/A _1245_/B _1245_/C VGND VGND VPWR VPWR _1245_/X sky130_fd_sc_hd__and3_2
XFILLER_2_94 VGND VGND VPWR VPWR sky130_fd_sc_hd__fill_2
X_1176_ _1190_/B _1190_/C _1190_/D _1190_/A VGND VGND VPWR VPWR _1176_/X sky130_fd_sc_hd__o31a_2
XFILLER_30_107 VGND VGND VPWR VPWR sky130_fd_sc_hd__decap_3
XFILLER_15_159 VGND VGND VPWR VPWR sky130_fd_sc_hd__fill_1
XFILLER_46_262 VGND VGND VPWR VPWR sky130_fd_sc_hd__fill_2
X_1030_ _2026_/Q _1152_/A VGND VGND VPWR VPWR _1265_/A sky130_fd_sc_hd__nand2_2
X_1932_ _2036_/CLK _1932_/D VGND VGND VPWR VPWR _1932_/Q sky130_fd_sc_hd__dfxtp_2
X_1863_ clkload5/A _1863_/D VGND VGND VPWR VPWR _1863_/Q sky130_fd_sc_hd__dfxtp_2
XFILLER_21_118 VGND VGND VPWR VPWR sky130_fd_sc_hd__decap_3
XFILLER_21_129 VGND VGND VPWR VPWR sky130_fd_sc_hd__fill_2
X_1794_ _1806_/A _1794_/B VGND VGND VPWR VPWR _1794_/X sky130_fd_sc_hd__or2_2
X_1228_ _1228_/A _1228_/B _1227_/X VGND VGND VPWR VPWR _1228_/X sky130_fd_sc_hd__or3b_2
XFILLER_52_276 VGND VGND VPWR VPWR sky130_fd_sc_hd__decap_3
X_1159_ _1159_/A _1160_/B VGND VGND VPWR VPWR _1225_/A sky130_fd_sc_hd__xor2_2
XFILLER_12_107 VGND VGND VPWR VPWR sky130_fd_sc_hd__decap_3
XFILLER_32_69 VGND VGND VPWR VPWR sky130_fd_sc_hd__fill_1
Xclkbuf_leaf_23_clk clkbuf_leaf_2_clk/A VGND VGND VPWR VPWR clkload2/A sky130_fd_sc_hd__clkbuf_8
XFILLER_7_177 VGND VGND VPWR VPWR sky130_fd_sc_hd__decap_3
X_2062_ _2064_/CLK _2062_/D VGND VGND VPWR VPWR _2062_/Q sky130_fd_sc_hd__dfxtp_2
XFILLER_34_265 VGND VGND VPWR VPWR sky130_fd_sc_hd__fill_1
X_1013_ _1859_/Q _1137_/A2 _1337_/B2 _1895_/Q _1012_/X VGND VGND VPWR VPWR _1222_/A
+ sky130_fd_sc_hd__a221o_2
X_1915_ clkload4/A _1915_/D VGND VGND VPWR VPWR uo_out[3] sky130_fd_sc_hd__dfxtp_2
X_1846_ _1903_/Q _1902_/Q _1846_/C _1846_/D VGND VGND VPWR VPWR _1848_/S sky130_fd_sc_hd__and4_2
Xclkbuf_leaf_14_clk clkbuf_leaf_3_clk/A VGND VGND VPWR VPWR clkload9/A sky130_fd_sc_hd__clkbuf_8
X_1777_ _1809_/A1 _2053_/Q _1779_/B1 _1776_/X VGND VGND VPWR VPWR _2054_/D sky130_fd_sc_hd__o211a_2
XPHY_EDGE_ROW_4_Right_4 VGND VGND VPWR VPWR sky130_fd_sc_hd__decap_3
XTAP_TAPCELL_ROW_4_136 VGND VPWR sky130_fd_sc_hd__tapvpwrvgnd_1
XFILLER_4_158 VGND VGND VPWR VPWR sky130_fd_sc_hd__decap_3
XFILLER_4_29 VGND VGND VPWR VPWR sky130_fd_sc_hd__decap_3
X_1631_ _1631_/A _1631_/B VGND VGND VPWR VPWR _1670_/B sky130_fd_sc_hd__or2_2
XFILLER_31_279 VGND VGND VPWR VPWR sky130_fd_sc_hd__fill_1
X_1700_ _2055_/Q _1697_/B _1699_/X _1749_/C1 VGND VGND VPWR VPWR _2018_/D sky130_fd_sc_hd__o211a_2
X_1562_ _1573_/C _1675_/A VGND VGND VPWR VPWR _1570_/B sky130_fd_sc_hd__or2_2
Xclkbuf_leaf_3_clk clkbuf_leaf_3_clk/A VGND VGND VPWR VPWR _2065_/CLK sky130_fd_sc_hd__clkbuf_8
X_1493_ _1521_/B _1493_/B VGND VGND VPWR VPWR _1496_/B sky130_fd_sc_hd__nand2_2
XTAP_TAPCELL_ROW_49_385 VGND VPWR sky130_fd_sc_hd__tapvpwrvgnd_1
X_2114_ _2114_/CLK _2114_/D VGND VGND VPWR VPWR _2114_/Q sky130_fd_sc_hd__dfxtp_2
XTAP_TAPCELL_ROW_1_117 VGND VPWR sky130_fd_sc_hd__tapvpwrvgnd_1
X_2045_ _2058_/CLK _2045_/D VGND VGND VPWR VPWR adc_en sky130_fd_sc_hd__dfxtp_2
Xfanout28 _1365_/B VGND VGND VPWR VPWR _1381_/B sky130_fd_sc_hd__clkdlybuf4s25_1
Xfanout39 _1136_/A VGND VGND VPWR VPWR _1145_/S sky130_fd_sc_hd__clkdlybuf4s25_1
XFILLER_13_38 VGND VGND VPWR VPWR sky130_fd_sc_hd__fill_2
XFILLER_22_235 VGND VGND VPWR VPWR sky130_fd_sc_hd__fill_1
X_1829_ _1830_/C _1829_/B VGND VGND VPWR VPWR _2077_/D sky130_fd_sc_hd__nor2_2
XFILLER_38_79 VGND VGND VPWR VPWR sky130_fd_sc_hd__decap_3
XFILLER_13_202 VGND VGND VPWR VPWR sky130_fd_sc_hd__decap_3
XTAP_TAPCELL_ROW_23_241 VGND VPWR sky130_fd_sc_hd__tapvpwrvgnd_1
XFILLER_36_305 VGND VGND VPWR VPWR sky130_fd_sc_hd__decap_3
XFILLER_0_172 VGND VGND VPWR VPWR sky130_fd_sc_hd__decap_3
XFILLER_0_194 VGND VGND VPWR VPWR sky130_fd_sc_hd__fill_2
XTAP_TAPCELL_ROW_46_366 VGND VPWR sky130_fd_sc_hd__tapvpwrvgnd_1
X_0993_ _0993_/A _1409_/B VGND VGND VPWR VPWR _1441_/A sky130_fd_sc_hd__nor2_2
X_1614_ _1614_/A _1614_/B VGND VGND VPWR VPWR _1618_/S sky130_fd_sc_hd__nor2_2
X_1545_ _1573_/C _1660_/A VGND VGND VPWR VPWR _1553_/B sky130_fd_sc_hd__or2_2
X_1476_ _2071_/Q _1743_/C VGND VGND VPWR VPWR _1711_/C sky130_fd_sc_hd__nor2_2
X_2028_ _2040_/CLK _2028_/D VGND VGND VPWR VPWR _2028_/Q sky130_fd_sc_hd__dfxtp_2
XTAP_TAPCELL_ROW_20_222 VGND VPWR sky130_fd_sc_hd__tapvpwrvgnd_1
XFILLER_49_67 VGND VGND VPWR VPWR sky130_fd_sc_hd__fill_1
XFILLER_5_253 VGND VGND VPWR VPWR sky130_fd_sc_hd__fill_2
XFILLER_39_6 VGND VGND VPWR VPWR sky130_fd_sc_hd__decap_3
X_1330_ _1863_/Q _1330_/B VGND VGND VPWR VPWR _1330_/X sky130_fd_sc_hd__or2_2
XFILLER_30_80 VGND VGND VPWR VPWR sky130_fd_sc_hd__decap_3
X_1261_ _1180_/A _1180_/B _1180_/C _1260_/Y VGND VGND VPWR VPWR _1261_/X sky130_fd_sc_hd__a31o_2
Xinput7 ui_in[4] VGND VGND VPWR VPWR input7/X sky130_fd_sc_hd__clkdlybuf4s25_1
XFILLER_51_116 VGND VGND VPWR VPWR sky130_fd_sc_hd__fill_1
XTAP_TAPCELL_ROW_34_303 VGND VPWR sky130_fd_sc_hd__tapvpwrvgnd_1
X_1192_ _1061_/X _1100_/A _1228_/B VGND VGND VPWR VPWR _1192_/X sky130_fd_sc_hd__o21ba_2
X_0976_ _2043_/Q _2042_/Q _2041_/Q VGND VGND VPWR VPWR a_selb1[0] sky130_fd_sc_hd__or3b_2
X_1459_ uo_out[0] _1457_/Y _1458_/Y VGND VGND VPWR VPWR _1912_/D sky130_fd_sc_hd__o21a_2
X_1528_ _1573_/C _1645_/A VGND VGND VPWR VPWR _1536_/B sky130_fd_sc_hd__or2_2
XFILLER_27_113 VGND VGND VPWR VPWR sky130_fd_sc_hd__decap_3
XFILLER_35_69 VGND VGND VPWR VPWR sky130_fd_sc_hd__fill_1
XFILLER_27_157 VGND VGND VPWR VPWR sky130_fd_sc_hd__decap_3
XFILLER_4_3 VGND VGND VPWR VPWR sky130_fd_sc_hd__decap_3
XFILLER_2_245 VGND VGND VPWR VPWR sky130_fd_sc_hd__decap_3
XFILLER_33_116 VGND VGND VPWR VPWR sky130_fd_sc_hd__decap_3
XFILLER_18_113 VGND VGND VPWR VPWR sky130_fd_sc_hd__fill_2
X_1244_ _1245_/C _1244_/B VGND VGND VPWR VPWR _1244_/Y sky130_fd_sc_hd__xnor2_2
X_1313_ _1325_/A _1394_/A VGND VGND VPWR VPWR _1313_/Y sky130_fd_sc_hd__nand2_2
XFILLER_24_116 VGND VGND VPWR VPWR sky130_fd_sc_hd__fill_2
X_1175_ _1167_/A _1167_/B _1174_/Y VGND VGND VPWR VPWR _1190_/D sky130_fd_sc_hd__a21oi_2
XFILLER_32_193 VGND VGND VPWR VPWR sky130_fd_sc_hd__decap_3
XFILLER_32_182 VGND VGND VPWR VPWR sky130_fd_sc_hd__decap_3
X_0959_ _0961_/C _0959_/B VGND VGND VPWR VPWR _2089_/D sky130_fd_sc_hd__nor2_2
XFILLER_15_116 VGND VGND VPWR VPWR sky130_fd_sc_hd__decap_3
X_1931_ clkload3/A _1931_/D VGND VGND VPWR VPWR _1931_/Q sky130_fd_sc_hd__dfxtp_2
X_1862_ _1897_/CLK _1862_/D VGND VGND VPWR VPWR _1862_/Q sky130_fd_sc_hd__dfxtp_2
X_1793_ _1807_/A1 _1790_/B _1809_/B1 _1792_/X VGND VGND VPWR VPWR _2062_/D sky130_fd_sc_hd__o211a_2
XTAP_TAPCELL_ROW_16_199 VGND VPWR sky130_fd_sc_hd__tapvpwrvgnd_1
XFILLER_52_200 VGND VGND VPWR VPWR sky130_fd_sc_hd__decap_3
X_1227_ _1227_/A _1227_/B _1227_/C VGND VGND VPWR VPWR _1227_/X sky130_fd_sc_hd__or3_2
X_1158_ _1158_/A _1160_/B VGND VGND VPWR VPWR _1249_/A sky130_fd_sc_hd__xor2_2
XFILLER_52_244 VGND VGND VPWR VPWR sky130_fd_sc_hd__decap_3
X_1089_ _1083_/X _1088_/X _1145_/S VGND VGND VPWR VPWR _1089_/X sky130_fd_sc_hd__mux2_1
XFILLER_20_141 VGND VGND VPWR VPWR sky130_fd_sc_hd__fill_2
XFILLER_32_59 VGND VGND VPWR VPWR sky130_fd_sc_hd__decap_3
XFILLER_4_318 VGND VGND VPWR VPWR sky130_fd_sc_hd__decap_3
XFILLER_4_307 VGND VGND VPWR VPWR sky130_fd_sc_hd__fill_1
XFILLER_43_233 VGND VGND VPWR VPWR sky130_fd_sc_hd__decap_3
XFILLER_28_241 VGND VGND VPWR VPWR sky130_fd_sc_hd__decap_3
XFILLER_7_145 VGND VGND VPWR VPWR sky130_fd_sc_hd__decap_3
XFILLER_11_163 VGND VGND VPWR VPWR sky130_fd_sc_hd__decap_3
XFILLER_22_70 VGND VGND VPWR VPWR sky130_fd_sc_hd__fill_1
X_1012_ _1871_/Q _1138_/A2 _1138_/B1 _1883_/Q VGND VGND VPWR VPWR _1012_/X sky130_fd_sc_hd__a22o_2
X_2061_ _2064_/CLK _2061_/D VGND VGND VPWR VPWR _2061_/Q sky130_fd_sc_hd__dfxtp_2
XFILLER_19_230 VGND VGND VPWR VPWR sky130_fd_sc_hd__fill_1
XFILLER_21_6 VGND VGND VPWR VPWR sky130_fd_sc_hd__decap_3
X_1914_ _2115_/CLK _1914_/D VGND VGND VPWR VPWR uo_out[2] sky130_fd_sc_hd__dfxtp_2
XFILLER_19_296 VGND VGND VPWR VPWR sky130_fd_sc_hd__decap_3
X_1845_ hold137/X _1840_/B _1845_/S VGND VGND VPWR VPWR _2112_/D sky130_fd_sc_hd__mux2_1
X_1776_ _1808_/A _2054_/Q VGND VGND VPWR VPWR _1776_/X sky130_fd_sc_hd__or2_2
XFILLER_8_94 VGND VGND VPWR VPWR sky130_fd_sc_hd__decap_3
XTAP_TAPCELL_ROW_12_180 VGND VPWR sky130_fd_sc_hd__tapvpwrvgnd_1
XTAP_TAPCELL_ROW_4_137 VGND VPWR sky130_fd_sc_hd__tapvpwrvgnd_1
XFILLER_25_277 VGND VGND VPWR VPWR sky130_fd_sc_hd__decap_3
XFILLER_0_321 VGND VGND VPWR VPWR sky130_fd_sc_hd__decap_3
XFILLER_31_225 VGND VGND VPWR VPWR sky130_fd_sc_hd__decap_3
XFILLER_31_203 VGND VGND VPWR VPWR sky130_fd_sc_hd__fill_2
XFILLER_16_200 VGND VGND VPWR VPWR sky130_fd_sc_hd__decap_3
X_1630_ _1631_/A _1631_/B VGND VGND VPWR VPWR _1640_/B sky130_fd_sc_hd__nor2_2
X_1561_ _2063_/Q _2062_/Q _2061_/Q VGND VGND VPWR VPWR _1675_/A sky130_fd_sc_hd__nand3_2
X_1492_ _1521_/B _1493_/B VGND VGND VPWR VPWR _1631_/B sky130_fd_sc_hd__and2_2
X_2113_ _2115_/CLK _2113_/D VGND VGND VPWR VPWR _2113_/Q sky130_fd_sc_hd__dfxtp_2
X_2044_ _2058_/CLK _2044_/D VGND VGND VPWR VPWR _2044_/Q sky130_fd_sc_hd__dfxtp_2
XTAP_TAPCELL_ROW_1_118 VGND VPWR sky130_fd_sc_hd__tapvpwrvgnd_1
Xfanout29 _1358_/Y VGND VGND VPWR VPWR _1365_/B sky130_fd_sc_hd__clkdlybuf4s25_1
X_1759_ _2056_/Q _1764_/B _1758_/X _1789_/B1 VGND VGND VPWR VPWR _2045_/D sky130_fd_sc_hd__o211a_2
X_1828_ _2076_/Q _1825_/B _1827_/X VGND VGND VPWR VPWR _1829_/B sky130_fd_sc_hd__a21oi_2
XFILLER_9_207 VGND VGND VPWR VPWR sky130_fd_sc_hd__fill_1
XFILLER_13_225 VGND VGND VPWR VPWR sky130_fd_sc_hd__decap_3
XTAP_TAPCELL_ROW_23_242 VGND VPWR sky130_fd_sc_hd__tapvpwrvgnd_1
XFILLER_48_133 VGND VGND VPWR VPWR sky130_fd_sc_hd__fill_1
XFILLER_36_317 VGND VGND VPWR VPWR sky130_fd_sc_hd__decap_3
XTAP_TAPCELL_ROW_46_367 VGND VPWR sky130_fd_sc_hd__tapvpwrvgnd_1
X_0992_ _1908_/Q _1907_/Q VGND VGND VPWR VPWR _1409_/B sky130_fd_sc_hd__and2b_2
X_1544_ _1792_/B _1790_/B _1794_/B VGND VGND VPWR VPWR _1660_/A sky130_fd_sc_hd__nand3b_2
XFILLER_8_284 VGND VGND VPWR VPWR sky130_fd_sc_hd__decap_3
XFILLER_8_295 VGND VGND VPWR VPWR sky130_fd_sc_hd__fill_2
X_1613_ hold136/X _1626_/B _1613_/S VGND VGND VPWR VPWR _1975_/D sky130_fd_sc_hd__mux2_1
XFILLER_39_166 VGND VGND VPWR VPWR sky130_fd_sc_hd__fill_2
X_1475_ _1483_/B _1484_/B _1483_/C _1475_/D VGND VGND VPWR VPWR _1743_/C sky130_fd_sc_hd__or4_2
X_2027_ _2040_/CLK _2027_/D VGND VGND VPWR VPWR _2027_/Q sky130_fd_sc_hd__dfxtp_2
XFILLER_40_59 VGND VGND VPWR VPWR sky130_fd_sc_hd__fill_1
XFILLER_40_26 VGND VGND VPWR VPWR sky130_fd_sc_hd__fill_2
XFILLER_10_228 VGND VGND VPWR VPWR sky130_fd_sc_hd__decap_3
XTAP_TAPCELL_ROW_20_223 VGND VPWR sky130_fd_sc_hd__tapvpwrvgnd_1
XFILLER_18_306 VGND VGND VPWR VPWR sky130_fd_sc_hd__fill_2
XFILLER_18_317 VGND VGND VPWR VPWR sky130_fd_sc_hd__decap_3
XTAP_TAPCELL_ROW_43_348 VGND VPWR sky130_fd_sc_hd__tapvpwrvgnd_1
XFILLER_14_60 VGND VGND VPWR VPWR sky130_fd_sc_hd__fill_1
XTAP_TAPCELL_ROW_51_392 VGND VPWR sky130_fd_sc_hd__tapvpwrvgnd_1
XFILLER_5_265 VGND VGND VPWR VPWR sky130_fd_sc_hd__fill_1
XFILLER_5_287 VGND VGND VPWR VPWR sky130_fd_sc_hd__decap_3
XFILLER_14_93 VGND VGND VPWR VPWR sky130_fd_sc_hd__decap_3
X_1191_ _1180_/A _1180_/C _1190_/Y _1176_/X VGND VGND VPWR VPWR _1191_/X sky130_fd_sc_hd__a211o_2
X_1260_ _1260_/A _1260_/B VGND VGND VPWR VPWR _1260_/Y sky130_fd_sc_hd__xnor2_2
XFILLER_32_320 VGND VGND VPWR VPWR sky130_fd_sc_hd__decap_3
X_0975_ a_selb0[3] VGND VGND VPWR VPWR a_sel0[3] sky130_fd_sc_hd__inv_2
X_1527_ _1794_/B _1614_/A VGND VGND VPWR VPWR _1645_/A sky130_fd_sc_hd__or2_2
X_1458_ _1447_/B _2134_/A _1830_/C VGND VGND VPWR VPWR _1458_/Y sky130_fd_sc_hd__a21oi_2
X_1389_ _1890_/Q _1390_/B _1388_/Y _1389_/C1 VGND VGND VPWR VPWR _1890_/D sky130_fd_sc_hd__o211a_2
XFILLER_50_194 VGND VGND VPWR VPWR sky130_fd_sc_hd__fill_2
XFILLER_42_106 VGND VGND VPWR VPWR sky130_fd_sc_hd__decap_3
XFILLER_27_169 VGND VGND VPWR VPWR sky130_fd_sc_hd__fill_1
XFILLER_2_224 VGND VGND VPWR VPWR sky130_fd_sc_hd__decap_3
XFILLER_33_128 VGND VGND VPWR VPWR sky130_fd_sc_hd__decap_3
XFILLER_41_161 VGND VGND VPWR VPWR sky130_fd_sc_hd__decap_3
XFILLER_2_85 VGND VGND VPWR VPWR sky130_fd_sc_hd__decap_3
X_1243_ _1695_/A _1309_/A VGND VGND VPWR VPWR _1254_/C sky130_fd_sc_hd__xnor2_2
X_1174_ _1206_/B _1198_/A VGND VGND VPWR VPWR _1174_/Y sky130_fd_sc_hd__nand2_2
X_1312_ _1312_/A _1324_/B VGND VGND VPWR VPWR _1394_/A sky130_fd_sc_hd__nand2_2
XFILLER_20_323 VGND VGND VPWR VPWR sky130_fd_sc_hd__fill_1
X_0958_ _2088_/Q _0957_/C _2089_/Q VGND VGND VPWR VPWR _0959_/B sky130_fd_sc_hd__a21oi_2
XPHY_EDGE_ROW_6_Left_59 VGND VGND VPWR VPWR sky130_fd_sc_hd__decap_3
XFILLER_23_183 VGND VGND VPWR VPWR sky130_fd_sc_hd__decap_3
XFILLER_11_323 VGND VGND VPWR VPWR sky130_fd_sc_hd__fill_1
XFILLER_11_94 VGND VGND VPWR VPWR sky130_fd_sc_hd__decap_3
X_1930_ clkload3/A _1930_/D VGND VGND VPWR VPWR _1930_/Q sky130_fd_sc_hd__dfxtp_2
X_1861_ _1897_/CLK _1861_/D VGND VGND VPWR VPWR _1861_/Q sky130_fd_sc_hd__dfxtp_2
X_1792_ _1806_/A _1792_/B VGND VGND VPWR VPWR _1792_/X sky130_fd_sc_hd__or2_2
XFILLER_37_242 VGND VGND VPWR VPWR sky130_fd_sc_hd__fill_1
X_1157_ _1158_/A _1160_/B VGND VGND VPWR VPWR _1216_/A sky130_fd_sc_hd__or2_2
X_1226_ _1180_/A _1180_/B _1180_/C _1225_/X VGND VGND VPWR VPWR _1226_/X sky130_fd_sc_hd__a31o_2
XFILLER_52_256 VGND VGND VPWR VPWR sky130_fd_sc_hd__decap_3
X_1088_ _1999_/Q _2003_/Q _2007_/Q _2011_/Q _1143_/S0 _1141_/S1 VGND VGND VPWR VPWR
+ _1088_/X sky130_fd_sc_hd__mux4_2
XFILLER_20_120 VGND VGND VPWR VPWR sky130_fd_sc_hd__decap_3
XFILLER_20_197 VGND VGND VPWR VPWR sky130_fd_sc_hd__fill_2
XFILLER_43_256 VGND VGND VPWR VPWR sky130_fd_sc_hd__fill_1
XFILLER_28_253 VGND VGND VPWR VPWR sky130_fd_sc_hd__fill_1
XFILLER_7_113 VGND VGND VPWR VPWR sky130_fd_sc_hd__decap_3
XFILLER_7_157 VGND VGND VPWR VPWR sky130_fd_sc_hd__decap_3
X_1011_ _1860_/Q _1137_/A2 _1337_/B2 _1896_/Q _1010_/X VGND VGND VPWR VPWR _1208_/A
+ sky130_fd_sc_hd__a221o_2
XFILLER_34_234 VGND VGND VPWR VPWR sky130_fd_sc_hd__fill_1
X_2060_ clkload1/A _2060_/D VGND VGND VPWR VPWR _2060_/Q sky130_fd_sc_hd__dfxtp_2
XFILLER_19_220 VGND VGND VPWR VPWR sky130_fd_sc_hd__decap_3
XFILLER_19_242 VGND VGND VPWR VPWR sky130_fd_sc_hd__decap_3
X_1913_ _2115_/CLK _1913_/D VGND VGND VPWR VPWR uo_out[1] sky130_fd_sc_hd__dfxtp_2
X_1844_ hold139/X _1834_/Y _1845_/S VGND VGND VPWR VPWR _2111_/D sky130_fd_sc_hd__mux2_1
X_1775_ _1809_/A1 _1772_/B _1779_/B1 _1774_/X VGND VGND VPWR VPWR _2053_/D sky130_fd_sc_hd__o211a_2
XTAP_TAPCELL_ROW_12_181 VGND VPWR sky130_fd_sc_hd__tapvpwrvgnd_1
XTAP_TAPCELL_ROW_4_138 VGND VPWR sky130_fd_sc_hd__tapvpwrvgnd_1
XFILLER_43_26 VGND VGND VPWR VPWR sky130_fd_sc_hd__fill_2
XFILLER_25_289 VGND VGND VPWR VPWR sky130_fd_sc_hd__decap_3
XFILLER_25_223 VGND VGND VPWR VPWR sky130_fd_sc_hd__fill_1
X_1209_ _1200_/B _1208_/Y _1264_/B VGND VGND VPWR VPWR _1209_/X sky130_fd_sc_hd__a21o_2
XFILLER_4_149 VGND VGND VPWR VPWR sky130_fd_sc_hd__decap_3
XPHY_EDGE_ROW_9_Left_62 VGND VGND VPWR VPWR sky130_fd_sc_hd__decap_3
XFILLER_16_289 VGND VGND VPWR VPWR sky130_fd_sc_hd__decap_3
X_1560_ hold143/X _1626_/B _1560_/S VGND VGND VPWR VPWR _1943_/D sky130_fd_sc_hd__mux2_1
X_2112_ _2115_/CLK _2112_/D VGND VGND VPWR VPWR _2112_/Q sky130_fd_sc_hd__dfxtp_2
X_1491_ _2065_/Q _1500_/A VGND VGND VPWR VPWR _1493_/B sky130_fd_sc_hd__nand2_2
XFILLER_3_160 VGND VGND VPWR VPWR sky130_fd_sc_hd__decap_3
XFILLER_12_3 VGND VGND VPWR VPWR sky130_fd_sc_hd__fill_2
X_2043_ _2058_/CLK _2043_/D VGND VGND VPWR VPWR _2043_/Q sky130_fd_sc_hd__dfxtp_2
XTAP_TAPCELL_ROW_1_119 VGND VPWR sky130_fd_sc_hd__tapvpwrvgnd_1
Xfanout19 _1686_/X VGND VGND VPWR VPWR _1697_/B sky130_fd_sc_hd__clkdlybuf4s25_1
XTAP_TAPCELL_ROW_32_287 VGND VPWR sky130_fd_sc_hd__tapvpwrvgnd_1
X_1827_ _2093_/D _2093_/Q _2077_/Q VGND VGND VPWR VPWR _1827_/X sky130_fd_sc_hd__o21a_2
X_1758_ adc_en _1760_/B VGND VGND VPWR VPWR _1758_/X sky130_fd_sc_hd__or2_2
X_1689_ _2013_/Q _1707_/B VGND VGND VPWR VPWR _1689_/X sky130_fd_sc_hd__or2_2
XPHY_EDGE_ROW_35_Left_88 VGND VGND VPWR VPWR sky130_fd_sc_hd__decap_3
XFILLER_9_219 VGND VGND VPWR VPWR sky130_fd_sc_hd__decap_3
XFILLER_13_259 VGND VGND VPWR VPWR sky130_fd_sc_hd__fill_2
XFILLER_21_281 VGND VGND VPWR VPWR sky130_fd_sc_hd__decap_3
XFILLER_0_141 VGND VGND VPWR VPWR sky130_fd_sc_hd__decap_3
XFILLER_0_185 VGND VGND VPWR VPWR sky130_fd_sc_hd__fill_1
XTAP_TAPCELL_ROW_46_368 VGND VPWR sky130_fd_sc_hd__tapvpwrvgnd_1
X_0991_ _1907_/Q _1908_/Q VGND VGND VPWR VPWR _0991_/Y sky130_fd_sc_hd__nand2b_2
X_1543_ hold169/X _1626_/B _1543_/S VGND VGND VPWR VPWR _1935_/D sky130_fd_sc_hd__mux2_1
X_1612_ hold197/X _1624_/B _1613_/S VGND VGND VPWR VPWR _1974_/D sky130_fd_sc_hd__mux2_1
X_1474_ _2077_/Q _2076_/Q VGND VGND VPWR VPWR _1475_/D sky130_fd_sc_hd__nand2_2
XFILLER_39_189 VGND VGND VPWR VPWR sky130_fd_sc_hd__decap_3
X_2026_ _2040_/CLK _2026_/D VGND VGND VPWR VPWR _2026_/Q sky130_fd_sc_hd__dfxtp_2
XTAP_TAPCELL_ROW_20_224 VGND VPWR sky130_fd_sc_hd__tapvpwrvgnd_1
XFILLER_49_25 VGND VGND VPWR VPWR sky130_fd_sc_hd__fill_2
XTAP_TAPCELL_ROW_51_393 VGND VPWR sky130_fd_sc_hd__tapvpwrvgnd_1
XTAP_TAPCELL_ROW_43_349 VGND VPWR sky130_fd_sc_hd__tapvpwrvgnd_1
XFILLER_30_71 VGND VGND VPWR VPWR sky130_fd_sc_hd__decap_3
XFILLER_5_244 VGND VGND VPWR VPWR sky130_fd_sc_hd__decap_3
XFILLER_36_126 VGND VGND VPWR VPWR sky130_fd_sc_hd__decap_3
X_1190_ _1190_/A _1190_/B _1190_/C _1190_/D VGND VGND VPWR VPWR _1190_/Y sky130_fd_sc_hd__nor4_2
X_0974_ _2039_/Q _2038_/Q _2040_/Q VGND VGND VPWR VPWR a_selb0[3] sky130_fd_sc_hd__or3b_2
X_1457_ _1457_/A _1464_/B VGND VGND VPWR VPWR _1457_/Y sky130_fd_sc_hd__nor2_2
X_1526_ _1792_/B _1790_/B VGND VGND VPWR VPWR _1614_/A sky130_fd_sc_hd__nand2_2
X_1388_ _1388_/A _1390_/B VGND VGND VPWR VPWR _1388_/Y sky130_fd_sc_hd__nand2_2
XFILLER_27_104 VGND VGND VPWR VPWR sky130_fd_sc_hd__decap_3
X_2009_ clkload4/A _2009_/D VGND VGND VPWR VPWR _2009_/Q sky130_fd_sc_hd__dfxtp_2
Xdig_top_95 VGND VGND VPWR VPWR dig_top_95/HI uio_oe[1] sky130_fd_sc_hd__conb_1
XFILLER_41_140 VGND VGND VPWR VPWR sky130_fd_sc_hd__fill_1
XFILLER_14_321 VGND VGND VPWR VPWR sky130_fd_sc_hd__decap_3
XPHY_EDGE_ROW_38_Left_91 VGND VGND VPWR VPWR sky130_fd_sc_hd__decap_3
XFILLER_25_93 VGND VGND VPWR VPWR sky130_fd_sc_hd__fill_2
X_1311_ _1856_/Q _1310_/A _1310_/Y _1395_/C1 VGND VGND VPWR VPWR _1856_/D sky130_fd_sc_hd__o211a_2
XPHY_EDGE_ROW_22_Left_75 VGND VGND VPWR VPWR sky130_fd_sc_hd__decap_3
XFILLER_2_42 VGND VGND VPWR VPWR sky130_fd_sc_hd__fill_1
X_1242_ _1279_/A1 _1241_/X _1238_/X VGND VGND VPWR VPWR _1309_/A sky130_fd_sc_hd__a21oi_2
XPHY_EDGE_ROW_10_Right_10 VGND VGND VPWR VPWR sky130_fd_sc_hd__decap_3
X_1173_ _1190_/C _1173_/B VGND VGND VPWR VPWR _1198_/A sky130_fd_sc_hd__nor2_2
X_0957_ _2088_/Q _2089_/Q _0957_/C VGND VGND VPWR VPWR _0961_/C sky130_fd_sc_hd__and3_2
X_1509_ _1922_/Q _1514_/B VGND VGND VPWR VPWR _1509_/X sky130_fd_sc_hd__and2_2
Xmax_cap38 _1489_/Y VGND VGND VPWR VPWR _1518_/A1 sky130_fd_sc_hd__buf_1
XFILLER_7_317 VGND VGND VPWR VPWR sky130_fd_sc_hd__decap_3
XFILLER_11_302 VGND VGND VPWR VPWR sky130_fd_sc_hd__decap_3
X_1860_ _1897_/CLK _1860_/D VGND VGND VPWR VPWR _1860_/Q sky130_fd_sc_hd__dfxtp_2
X_1791_ _1816_/A _2060_/Q _1809_/B1 _1790_/X VGND VGND VPWR VPWR _2061_/D sky130_fd_sc_hd__o211a_2
X_1087_ _1147_/A _1146_/S VGND VGND VPWR VPWR _1087_/Y sky130_fd_sc_hd__nor2_2
Xclkbuf_leaf_17_clk clkbuf_2_2__f_clk/X VGND VGND VPWR VPWR clkload6/A sky130_fd_sc_hd__clkbuf_8
X_1225_ _1225_/A _1225_/B VGND VGND VPWR VPWR _1225_/X sky130_fd_sc_hd__xor2_2
X_1156_ _1163_/A _1267_/A _1163_/C VGND VGND VPWR VPWR _1240_/A sky130_fd_sc_hd__nand3_2
XFILLER_16_29 VGND VGND VPWR VPWR sky130_fd_sc_hd__decap_3
XFILLER_52_279 VGND VGND VPWR VPWR sky130_fd_sc_hd__fill_1
X_1989_ clkload5/A _1989_/D VGND VGND VPWR VPWR _1989_/Q sky130_fd_sc_hd__dfxtp_2
XFILLER_4_309 VGND VGND VPWR VPWR sky130_fd_sc_hd__decap_3
XFILLER_28_232 VGND VGND VPWR VPWR sky130_fd_sc_hd__decap_3
XFILLER_28_276 VGND VGND VPWR VPWR sky130_fd_sc_hd__decap_3
XFILLER_11_198 VGND VGND VPWR VPWR sky130_fd_sc_hd__decap_3
X_1010_ _1872_/Q _1138_/A2 _1138_/B1 _1884_/Q VGND VGND VPWR VPWR _1010_/X sky130_fd_sc_hd__a22o_2
XTAP_TAPCELL_ROW_29_271 VGND VPWR sky130_fd_sc_hd__tapvpwrvgnd_1
XFILLER_19_265 VGND VGND VPWR VPWR sky130_fd_sc_hd__decap_3
X_1912_ _2115_/CLK _1912_/D VGND VGND VPWR VPWR uo_out[0] sky130_fd_sc_hd__dfxtp_2
X_1843_ hold125/X _1832_/X _1845_/S VGND VGND VPWR VPWR _2110_/D sky130_fd_sc_hd__mux2_1
XFILLER_42_290 VGND VGND VPWR VPWR sky130_fd_sc_hd__fill_1
XFILLER_8_85 VGND VGND VPWR VPWR sky130_fd_sc_hd__decap_3
Xclkbuf_leaf_6_clk clkbuf_leaf_9_clk/A VGND VGND VPWR VPWR _2035_/CLK sky130_fd_sc_hd__clkbuf_8
X_1774_ _1808_/A _2053_/Q VGND VGND VPWR VPWR _1774_/X sky130_fd_sc_hd__or2_2
XTAP_TAPCELL_ROW_12_182 VGND VPWR sky130_fd_sc_hd__tapvpwrvgnd_1
XFILLER_27_17 VGND VGND VPWR VPWR sky130_fd_sc_hd__fill_2
X_1208_ _1208_/A _1208_/B VGND VGND VPWR VPWR _1208_/Y sky130_fd_sc_hd__nand2_2
X_1139_ _1137_/X _1138_/X _1087_/Y _1136_/X VGND VGND VPWR VPWR _1181_/B sky130_fd_sc_hd__o211a_2
XFILLER_25_268 VGND VGND VPWR VPWR sky130_fd_sc_hd__fill_1
XFILLER_0_312 VGND VGND VPWR VPWR sky130_fd_sc_hd__decap_3
XFILLER_16_224 VGND VGND VPWR VPWR sky130_fd_sc_hd__fill_2
XFILLER_33_82 VGND VGND VPWR VPWR sky130_fd_sc_hd__decap_3
X_1490_ _1794_/B _1792_/B _1790_/B VGND VGND VPWR VPWR _1629_/B sky130_fd_sc_hd__or3b_2
XFILLER_3_172 VGND VGND VPWR VPWR sky130_fd_sc_hd__decap_3
X_2111_ _2114_/CLK _2111_/D VGND VGND VPWR VPWR _2111_/Q sky130_fd_sc_hd__dfxtp_2
XFILLER_3_183 VGND VGND VPWR VPWR sky130_fd_sc_hd__decap_3
X_2042_ _2058_/CLK _2042_/D VGND VGND VPWR VPWR _2042_/Q sky130_fd_sc_hd__dfxtp_2
XPHY_EDGE_ROW_8_Right_8 VGND VGND VPWR VPWR sky130_fd_sc_hd__decap_3
XTAP_TAPCELL_ROW_32_288 VGND VPWR sky130_fd_sc_hd__tapvpwrvgnd_1
XFILLER_30_271 VGND VGND VPWR VPWR sky130_fd_sc_hd__fill_1
X_1826_ _1483_/A _1824_/C _1825_/X _1824_/A VGND VGND VPWR VPWR _2076_/D sky130_fd_sc_hd__o211a_2
XPHY_EDGE_ROW_39_Right_39 VGND VGND VPWR VPWR sky130_fd_sc_hd__decap_3
X_1757_ _2055_/Q _1764_/B _1756_/X _1789_/B1 VGND VGND VPWR VPWR _2044_/D sky130_fd_sc_hd__o211a_2
X_1688_ _1521_/A _1697_/B _1687_/X _1809_/B1 VGND VGND VPWR VPWR _2012_/D sky130_fd_sc_hd__o211a_2
XPHY_EDGE_ROW_48_Right_48 VGND VGND VPWR VPWR sky130_fd_sc_hd__decap_3
XFILLER_13_205 VGND VGND VPWR VPWR sky130_fd_sc_hd__fill_1
XFILLER_0_131 VGND VGND VPWR VPWR sky130_fd_sc_hd__decap_3
XFILLER_0_175 VGND VGND VPWR VPWR sky130_fd_sc_hd__fill_1
XFILLER_0_197 VGND VGND VPWR VPWR sky130_fd_sc_hd__decap_3
XTAP_TAPCELL_ROW_46_369 VGND VPWR sky130_fd_sc_hd__tapvpwrvgnd_1
X_0990_ _1907_/Q _1908_/Q VGND VGND VPWR VPWR _0993_/A sky130_fd_sc_hd__and2b_2
X_1611_ hold156/X _1622_/B _1613_/S VGND VGND VPWR VPWR _1973_/D sky130_fd_sc_hd__mux2_1
X_1542_ hold152/X _1624_/B _1543_/S VGND VGND VPWR VPWR _1934_/D sky130_fd_sc_hd__mux2_1
X_1473_ _2074_/Q _2073_/Q VGND VGND VPWR VPWR _1483_/C sky130_fd_sc_hd__or2_2
Xdig_top VGND VGND VPWR VPWR dig_top/HI uio_oe[0] sky130_fd_sc_hd__conb_1
XFILLER_39_113 VGND VGND VPWR VPWR sky130_fd_sc_hd__fill_1
X_2025_ _2068_/CLK _2025_/D VGND VGND VPWR VPWR _2025_/Q sky130_fd_sc_hd__dfxtp_2
XFILLER_24_29 VGND VGND VPWR VPWR sky130_fd_sc_hd__fill_2
X_1809_ _1809_/A1 _2069_/Q _1809_/B1 _1808_/X VGND VGND VPWR VPWR _2070_/D sky130_fd_sc_hd__o211a_2
XTAP_TAPCELL_ROW_20_225 VGND VPWR sky130_fd_sc_hd__tapvpwrvgnd_1
XFILLER_38_190 VGND VGND VPWR VPWR sky130_fd_sc_hd__decap_3
XTAP_TAPCELL_ROW_51_394 VGND VPWR sky130_fd_sc_hd__tapvpwrvgnd_1
XFILLER_30_83 VGND VGND VPWR VPWR sky130_fd_sc_hd__fill_1
X_0973_ a_selb0[2] VGND VGND VPWR VPWR a_sel0[2] sky130_fd_sc_hd__inv_2
X_1456_ _1908_/Q _1907_/Q _1455_/X VGND VGND VPWR VPWR _1464_/B sky130_fd_sc_hd__a21bo_2
X_1525_ _1626_/B hold191/X _1525_/S VGND VGND VPWR VPWR _1927_/D sky130_fd_sc_hd__mux2_1
X_1387_ _1889_/Q _1390_/B _1386_/Y _1723_/C1 VGND VGND VPWR VPWR _1889_/D sky130_fd_sc_hd__o211a_2
X_2008_ clkload4/A _2008_/D VGND VGND VPWR VPWR _2008_/Q sky130_fd_sc_hd__dfxtp_2
XFILLER_35_182 VGND VGND VPWR VPWR sky130_fd_sc_hd__decap_3
XFILLER_35_17 VGND VGND VPWR VPWR sky130_fd_sc_hd__fill_1
XFILLER_27_116 VGND VGND VPWR VPWR sky130_fd_sc_hd__fill_1
XFILLER_50_185 VGND VGND VPWR VPWR sky130_fd_sc_hd__decap_3
XFILLER_4_6 VGND VGND VPWR VPWR sky130_fd_sc_hd__decap_3
XFILLER_2_248 VGND VGND VPWR VPWR sky130_fd_sc_hd__decap_3
Xdig_top_96 VGND VGND VPWR VPWR dig_top_96/HI uio_oe[2] sky130_fd_sc_hd__conb_1
XFILLER_33_119 VGND VGND VPWR VPWR sky130_fd_sc_hd__fill_2
XFILLER_33_108 VGND VGND VPWR VPWR sky130_fd_sc_hd__decap_3
XFILLER_41_196 VGND VGND VPWR VPWR sky130_fd_sc_hd__decap_3
XFILLER_41_93 VGND VGND VPWR VPWR sky130_fd_sc_hd__fill_1
XFILLER_1_281 VGND VGND VPWR VPWR sky130_fd_sc_hd__decap_3
X_1241_ _1099_/Y _1180_/B _1180_/C _1240_/Y VGND VGND VPWR VPWR _1241_/X sky130_fd_sc_hd__a31o_2
X_1310_ _1310_/A _1392_/A VGND VGND VPWR VPWR _1310_/Y sky130_fd_sc_hd__nand2_2
X_1172_ _1201_/A _1172_/B VGND VGND VPWR VPWR _1173_/B sky130_fd_sc_hd__nor2_2
XFILLER_17_160 VGND VGND VPWR VPWR sky130_fd_sc_hd__decap_3
XFILLER_17_182 VGND VGND VPWR VPWR sky130_fd_sc_hd__decap_3
X_0956_ _2088_/Q _0957_/C VGND VGND VPWR VPWR _2088_/D sky130_fd_sc_hd__xor2_2
XFILLER_46_27 VGND VGND VPWR VPWR sky130_fd_sc_hd__fill_1
X_1439_ _1432_/A _1436_/C _1437_/X _1830_/C VGND VGND VPWR VPWR _1440_/B sky130_fd_sc_hd__a31o_2
X_1508_ _1518_/A1 _1497_/A _1505_/X _1504_/X VGND VGND VPWR VPWR _1921_/D sky130_fd_sc_hd__a31o_2
Xmax_cap17 _1760_/B VGND VGND VPWR VPWR _1754_/B sky130_fd_sc_hd__buf_1
XFILLER_23_141 VGND VGND VPWR VPWR sky130_fd_sc_hd__decap_3
XFILLER_23_130 VGND VGND VPWR VPWR sky130_fd_sc_hd__decap_3
XFILLER_15_119 VGND VGND VPWR VPWR sky130_fd_sc_hd__decap_3
XFILLER_11_74 VGND VGND VPWR VPWR sky130_fd_sc_hd__decap_3
XFILLER_36_82 VGND VGND VPWR VPWR sky130_fd_sc_hd__fill_2
X_1790_ _1806_/A _1790_/B VGND VGND VPWR VPWR _1790_/X sky130_fd_sc_hd__or2_2
XFILLER_35_3 VGND VGND VPWR VPWR sky130_fd_sc_hd__decap_3
X_1224_ _1279_/A1 _1219_/X _1221_/X _1223_/Y VGND VGND VPWR VPWR _1318_/A sky130_fd_sc_hd__a22o_2
XFILLER_52_247 VGND VGND VPWR VPWR sky130_fd_sc_hd__decap_3
X_1086_ _2105_/Q _2108_/Q _2111_/Q _2114_/Q _2116_/Q _2117_/Q VGND VGND VPWR VPWR
+ _1146_/S sky130_fd_sc_hd__mux4_2
X_1155_ _1104_/A _1172_/B _1260_/A _1260_/B _1118_/Y VGND VGND VPWR VPWR _1163_/C
+ sky130_fd_sc_hd__a221o_2
X_1988_ _2001_/CLK _1988_/D VGND VGND VPWR VPWR _1988_/Q sky130_fd_sc_hd__dfxtp_2
X_0939_ _2081_/Q _0940_/B VGND VGND VPWR VPWR _0943_/C sky130_fd_sc_hd__and2_2
XFILLER_28_244 VGND VGND VPWR VPWR sky130_fd_sc_hd__fill_2
XFILLER_28_200 VGND VGND VPWR VPWR sky130_fd_sc_hd__decap_3
Xclkbuf_2_2__f_clk clkbuf_0_clk/X VGND VGND VPWR VPWR clkbuf_2_2__f_clk/X sky130_fd_sc_hd__clkbuf_16
XFILLER_7_148 VGND VGND VPWR VPWR sky130_fd_sc_hd__decap_3
XFILLER_11_166 VGND VGND VPWR VPWR sky130_fd_sc_hd__fill_2
XFILLER_22_40 VGND VGND VPWR VPWR sky130_fd_sc_hd__decap_3
XFILLER_22_95 VGND VGND VPWR VPWR sky130_fd_sc_hd__decap_3
XFILLER_19_200 VGND VGND VPWR VPWR sky130_fd_sc_hd__fill_2
XFILLER_21_9 VGND VGND VPWR VPWR sky130_fd_sc_hd__fill_1
XTAP_TAPCELL_ROW_29_272 VGND VPWR sky130_fd_sc_hd__tapvpwrvgnd_1
XFILLER_19_277 VGND VGND VPWR VPWR sky130_fd_sc_hd__decap_3
XFILLER_19_299 VGND VGND VPWR VPWR sky130_fd_sc_hd__decap_3
X_1842_ _1902_/Q _1846_/C _1846_/D _1903_/Q VGND VGND VPWR VPWR _1845_/S sky130_fd_sc_hd__and4b_2
X_1911_ clkload9/A _1911_/D VGND VGND VPWR VPWR _1911_/Q sky130_fd_sc_hd__dfxtp_2
XFILLER_8_97 VGND VGND VPWR VPWR sky130_fd_sc_hd__fill_1
X_1773_ _1816_/A _1770_/B _1824_/A _1772_/X VGND VGND VPWR VPWR _2052_/D sky130_fd_sc_hd__o211a_2
XFILLER_6_192 VGND VGND VPWR VPWR sky130_fd_sc_hd__decap_3
X_1207_ _1180_/X _1206_/Y _1279_/A1 VGND VGND VPWR VPWR _1212_/A sky130_fd_sc_hd__o21a_2
X_1138_ _2000_/Q _1138_/A2 _1138_/B1 _2004_/Q _1082_/Y VGND VGND VPWR VPWR _1138_/X
+ sky130_fd_sc_hd__a221o_2
XFILLER_25_225 VGND VGND VPWR VPWR sky130_fd_sc_hd__decap_3
X_1069_ _1258_/B _1256_/B _1037_/Y VGND VGND VPWR VPWR _1263_/B sky130_fd_sc_hd__o21ai_2
XFILLER_4_129 VGND VGND VPWR VPWR sky130_fd_sc_hd__decap_3
XFILLER_16_203 VGND VGND VPWR VPWR sky130_fd_sc_hd__fill_2
XFILLER_16_269 VGND VGND VPWR VPWR sky130_fd_sc_hd__decap_3
XFILLER_31_228 VGND VGND VPWR VPWR sky130_fd_sc_hd__decap_3
X_2110_ _2114_/CLK _2110_/D VGND VGND VPWR VPWR _2110_/Q sky130_fd_sc_hd__dfxtp_2
X_2041_ _2058_/CLK _2041_/D VGND VGND VPWR VPWR _2041_/Q sky130_fd_sc_hd__dfxtp_2
XTAP_TAPCELL_ROW_32_289 VGND VPWR sky130_fd_sc_hd__tapvpwrvgnd_1
XFILLER_30_261 VGND VGND VPWR VPWR sky130_fd_sc_hd__decap_3
X_1756_ _1756_/A _1760_/B VGND VGND VPWR VPWR _1756_/X sky130_fd_sc_hd__or2_2
X_1825_ _2076_/Q _1825_/B VGND VGND VPWR VPWR _1825_/X sky130_fd_sc_hd__or2_2
X_1687_ _2012_/Q _1707_/B VGND VGND VPWR VPWR _1687_/X sky130_fd_sc_hd__or2_2
XTAP_TAPCELL_ROW_0_110 VGND VPWR sky130_fd_sc_hd__tapvpwrvgnd_1
XFILLER_13_228 VGND VGND VPWR VPWR sky130_fd_sc_hd__decap_3
XFILLER_0_110 VGND VGND VPWR VPWR sky130_fd_sc_hd__fill_2
XFILLER_8_287 VGND VGND VPWR VPWR sky130_fd_sc_hd__fill_1
X_1610_ hold130/X _1620_/B _1613_/S VGND VGND VPWR VPWR _1972_/D sky130_fd_sc_hd__mux2_1
X_1541_ hold180/X _1622_/B _1543_/S VGND VGND VPWR VPWR _1933_/D sky130_fd_sc_hd__mux2_1
XFILLER_5_87 VGND VGND VPWR VPWR sky130_fd_sc_hd__decap_3
X_1472_ _1816_/A _2093_/Q VGND VGND VPWR VPWR _1484_/B sky130_fd_sc_hd__nand2_2
XTAP_TAPCELL_ROW_37_315 VGND VPWR sky130_fd_sc_hd__tapvpwrvgnd_1
X_2024_ _2068_/CLK _2024_/D VGND VGND VPWR VPWR _2024_/Q sky130_fd_sc_hd__dfxtp_2
XTAP_TAPCELL_ROW_20_226 VGND VPWR sky130_fd_sc_hd__tapvpwrvgnd_1
X_1739_ _1739_/A _1739_/B VGND VGND VPWR VPWR _2036_/D sky130_fd_sc_hd__nor2_2
X_1808_ _1808_/A _2070_/Q VGND VGND VPWR VPWR _1808_/X sky130_fd_sc_hd__or2_2
XTAP_TAPCELL_ROW_51_395 VGND VPWR sky130_fd_sc_hd__tapvpwrvgnd_1
XFILLER_5_213 VGND VGND VPWR VPWR sky130_fd_sc_hd__decap_3
XFILLER_32_323 VGND VGND VPWR VPWR sky130_fd_sc_hd__fill_1
X_0972_ _2040_/Q _2039_/Q _2038_/Q VGND VGND VPWR VPWR a_selb0[2] sky130_fd_sc_hd__nand3b_2
X_1524_ _1624_/B hold196/X _1525_/S VGND VGND VPWR VPWR _1926_/D sky130_fd_sc_hd__mux2_1
X_1455_ _1447_/B _1292_/X _1294_/X _2134_/A VGND VGND VPWR VPWR _1455_/X sky130_fd_sc_hd__o31a_2
X_1386_ _1386_/A _1390_/B VGND VGND VPWR VPWR _1386_/Y sky130_fd_sc_hd__nand2_2
XFILLER_50_120 VGND VGND VPWR VPWR sky130_fd_sc_hd__decap_3
X_2007_ _2036_/CLK _2007_/D VGND VGND VPWR VPWR _2007_/Q sky130_fd_sc_hd__dfxtp_2
XFILLER_42_109 VGND VGND VPWR VPWR sky130_fd_sc_hd__decap_3
XFILLER_2_227 VGND VGND VPWR VPWR sky130_fd_sc_hd__decap_3
Xdig_top_97 VGND VGND VPWR VPWR dig_top_97/HI uio_oe[3] sky130_fd_sc_hd__conb_1
XFILLER_41_164 VGND VGND VPWR VPWR sky130_fd_sc_hd__decap_3
XFILLER_14_301 VGND VGND VPWR VPWR sky130_fd_sc_hd__decap_3
XFILLER_14_312 VGND VGND VPWR VPWR sky130_fd_sc_hd__fill_1
X_1240_ _1240_/A _1240_/B VGND VGND VPWR VPWR _1240_/Y sky130_fd_sc_hd__nand2_2
X_1171_ _1201_/A _1172_/B VGND VGND VPWR VPWR _1190_/C sky130_fd_sc_hd__and2_2
XFILLER_2_88 VGND VGND VPWR VPWR sky130_fd_sc_hd__decap_3
XFILLER_17_172 VGND VGND VPWR VPWR sky130_fd_sc_hd__fill_1
XFILLER_32_197 VGND VGND VPWR VPWR sky130_fd_sc_hd__decap_3
X_0955_ _0957_/C _0955_/B VGND VGND VPWR VPWR _2087_/D sky130_fd_sc_hd__nor2_2
X_1507_ _2050_/Q _1521_/B VGND VGND VPWR VPWR _1622_/B sky130_fd_sc_hd__and2_2
X_1438_ _1432_/A _1436_/C _1437_/X VGND VGND VPWR VPWR _1440_/A sky130_fd_sc_hd__a21oi_2
X_1369_ _1394_/A _1377_/B VGND VGND VPWR VPWR _1369_/Y sky130_fd_sc_hd__nand2_2
Xmax_cap18 _1762_/B VGND VGND VPWR VPWR _1760_/B sky130_fd_sc_hd__buf_1
XFILLER_23_186 VGND VGND VPWR VPWR sky130_fd_sc_hd__fill_2
XFILLER_7_308 VGND VGND VPWR VPWR sky130_fd_sc_hd__fill_2
XFILLER_11_20 VGND VGND VPWR VPWR sky130_fd_sc_hd__decap_3
XFILLER_11_97 VGND VGND VPWR VPWR sky130_fd_sc_hd__fill_2
XFILLER_28_3 VGND VGND VPWR VPWR sky130_fd_sc_hd__fill_1
X_1223_ _1178_/A _1210_/B _1222_/X _0991_/Y VGND VGND VPWR VPWR _1223_/Y sky130_fd_sc_hd__a31oi_2
X_1154_ _1260_/A _1153_/B _1118_/Y VGND VGND VPWR VPWR _1268_/A sky130_fd_sc_hd__a21o_2
XFILLER_52_259 VGND VGND VPWR VPWR sky130_fd_sc_hd__fill_1
X_1085_ _1085_/A VGND VGND VPWR VPWR _1147_/A sky130_fd_sc_hd__inv_2
X_1987_ _2001_/CLK _1987_/D VGND VGND VPWR VPWR _1987_/Q sky130_fd_sc_hd__dfxtp_2
X_0938_ _0940_/B _0938_/B VGND VGND VPWR VPWR _2080_/D sky130_fd_sc_hd__nor2_2
XFILLER_7_116 VGND VGND VPWR VPWR sky130_fd_sc_hd__decap_3
XFILLER_11_156 VGND VGND VPWR VPWR sky130_fd_sc_hd__fill_2
XFILLER_3_322 VGND VGND VPWR VPWR sky130_fd_sc_hd__fill_2
XFILLER_19_223 VGND VGND VPWR VPWR sky130_fd_sc_hd__fill_1
XFILLER_19_245 VGND VGND VPWR VPWR sky130_fd_sc_hd__fill_2
X_1910_ _2114_/CLK _1910_/D VGND VGND VPWR VPWR _1910_/Q sky130_fd_sc_hd__dfxtp_2
XTAP_TAPCELL_ROW_29_273 VGND VPWR sky130_fd_sc_hd__tapvpwrvgnd_1
X_1841_ _0930_/Y _1839_/S _1840_/Y hold193/X VGND VGND VPWR VPWR _2109_/D sky130_fd_sc_hd__o22ai_2
XFILLER_6_171 VGND VGND VPWR VPWR sky130_fd_sc_hd__decap_3
X_1772_ _2093_/D _1772_/B VGND VGND VPWR VPWR _1772_/X sky130_fd_sc_hd__or2_2
X_1137_ _1996_/Q _1137_/A2 _1441_/B _2008_/Q VGND VGND VPWR VPWR _1137_/X sky130_fd_sc_hd__a22o_2
XFILLER_25_248 VGND VGND VPWR VPWR sky130_fd_sc_hd__decap_3
XFILLER_25_237 VGND VGND VPWR VPWR sky130_fd_sc_hd__decap_3
X_1206_ _1206_/A _1206_/B VGND VGND VPWR VPWR _1206_/Y sky130_fd_sc_hd__xnor2_2
XFILLER_33_281 VGND VGND VPWR VPWR sky130_fd_sc_hd__fill_1
X_1068_ _1258_/B _1256_/B VGND VGND VPWR VPWR _1257_/A sky130_fd_sc_hd__nor2_2
XFILLER_48_318 VGND VGND VPWR VPWR sky130_fd_sc_hd__decap_3
XFILLER_48_307 VGND VGND VPWR VPWR sky130_fd_sc_hd__fill_1
XTAP_TAPCELL_ROW_3_130 VGND VPWR sky130_fd_sc_hd__tapvpwrvgnd_1
XTAP_TAPCELL_ROW_26_254 VGND VPWR sky130_fd_sc_hd__tapvpwrvgnd_1
XFILLER_33_95 VGND VGND VPWR VPWR sky130_fd_sc_hd__decap_3
X_2040_ _2040_/CLK _2040_/D VGND VGND VPWR VPWR _2040_/Q sky130_fd_sc_hd__dfxtp_2
XFILLER_15_281 VGND VGND VPWR VPWR sky130_fd_sc_hd__fill_1
XFILLER_15_292 VGND VGND VPWR VPWR sky130_fd_sc_hd__decap_3
X_1755_ _2054_/Q _1743_/X _1754_/X _1779_/B1 VGND VGND VPWR VPWR _2043_/D sky130_fd_sc_hd__o211a_2
X_1824_ _1824_/A _1824_/B _1824_/C VGND VGND VPWR VPWR _2075_/D sky130_fd_sc_hd__and3_2
X_1686_ _2069_/Q _1686_/B _2070_/Q VGND VGND VPWR VPWR _1686_/X sky130_fd_sc_hd__or3b_2
XTAP_TAPCELL_ROW_0_111 VGND VPWR sky130_fd_sc_hd__tapvpwrvgnd_1
XFILLER_21_284 VGND VGND VPWR VPWR sky130_fd_sc_hd__decap_3
XFILLER_0_144 VGND VGND VPWR VPWR sky130_fd_sc_hd__decap_3
XFILLER_28_73 VGND VGND VPWR VPWR sky130_fd_sc_hd__decap_3
XFILLER_0_155 VGND VGND VPWR VPWR sky130_fd_sc_hd__fill_2
XFILLER_44_83 VGND VGND VPWR VPWR sky130_fd_sc_hd__fill_1
X_1540_ hold192/X _1620_/B _1543_/S VGND VGND VPWR VPWR _1932_/D sky130_fd_sc_hd__mux2_1
XFILLER_10_3 VGND VGND VPWR VPWR sky130_fd_sc_hd__fill_2
X_1471_ _2075_/Q _2072_/Q _1830_/C VGND VGND VPWR VPWR _1483_/B sky130_fd_sc_hd__or3_2
XTAP_TAPCELL_ROW_45_360 VGND VPWR sky130_fd_sc_hd__tapvpwrvgnd_1
XTAP_TAPCELL_ROW_37_316 VGND VPWR sky130_fd_sc_hd__tapvpwrvgnd_1
X_2023_ _2068_/CLK _2023_/D VGND VGND VPWR VPWR _2023_/Q sky130_fd_sc_hd__dfxtp_2
X_1807_ _1807_/A1 _2068_/Q _1809_/B1 _1806_/X VGND VGND VPWR VPWR _2069_/D sky130_fd_sc_hd__o211a_2
X_1738_ _2036_/Q _1737_/B _1736_/B VGND VGND VPWR VPWR _1739_/B sky130_fd_sc_hd__o21ai_2
X_1669_ hold127/X _1661_/X _1668_/Y VGND VGND VPWR VPWR _2003_/D sky130_fd_sc_hd__a21o_2
XFILLER_38_170 VGND VGND VPWR VPWR sky130_fd_sc_hd__decap_3
XFILLER_26_321 VGND VGND VPWR VPWR sky130_fd_sc_hd__decap_3
XTAP_TAPCELL_ROW_51_396 VGND VPWR sky130_fd_sc_hd__tapvpwrvgnd_1
XFILLER_30_74 VGND VGND VPWR VPWR sky130_fd_sc_hd__fill_1
XFILLER_30_63 VGND VGND VPWR VPWR sky130_fd_sc_hd__fill_1
XFILLER_30_41 VGND VGND VPWR VPWR sky130_fd_sc_hd__decap_3
XFILLER_5_225 VGND VGND VPWR VPWR sky130_fd_sc_hd__fill_1
XFILLER_5_247 VGND VGND VPWR VPWR sky130_fd_sc_hd__decap_3
XFILLER_14_75 VGND VGND VPWR VPWR sky130_fd_sc_hd__decap_3
XFILLER_36_129 VGND VGND VPWR VPWR sky130_fd_sc_hd__fill_2
XFILLER_36_118 VGND VGND VPWR VPWR sky130_fd_sc_hd__fill_1
X_0971_ a_selb0[1] VGND VGND VPWR VPWR a_sel0[1] sky130_fd_sc_hd__inv_2
X_1454_ _1447_/X _1454_/B _1831_/C VGND VGND VPWR VPWR _1911_/D sky130_fd_sc_hd__and3b_2
X_1523_ _1622_/B _1925_/Q _1525_/S VGND VGND VPWR VPWR _1925_/D sky130_fd_sc_hd__mux2_1
X_1385_ _1888_/Q _1390_/B _1384_/Y _1389_/C1 VGND VGND VPWR VPWR _1888_/D sky130_fd_sc_hd__o211a_2
XFILLER_27_107 VGND VGND VPWR VPWR sky130_fd_sc_hd__decap_3
X_2006_ clkload4/A _2006_/D VGND VGND VPWR VPWR _2006_/Q sky130_fd_sc_hd__dfxtp_2
XFILLER_35_162 VGND VGND VPWR VPWR sky130_fd_sc_hd__decap_3
Xdig_top_98 VGND VGND VPWR VPWR dig_top_98/HI uio_oe[4] sky130_fd_sc_hd__conb_1
XFILLER_41_132 VGND VGND VPWR VPWR sky130_fd_sc_hd__fill_1
XFILLER_41_110 VGND VGND VPWR VPWR sky130_fd_sc_hd__fill_2
X_1170_ _1190_/B _1170_/B VGND VGND VPWR VPWR _1206_/B sky130_fd_sc_hd__nor2_2
X_0954_ _2087_/Q _0954_/B VGND VGND VPWR VPWR _0955_/B sky130_fd_sc_hd__nor2_2
X_1437_ _1905_/Q _1906_/Q VGND VGND VPWR VPWR _1437_/X sky130_fd_sc_hd__xor2_2
X_1506_ _1506_/A _1598_/A VGND VGND VPWR VPWR _1679_/A sky130_fd_sc_hd__nand2_2
XFILLER_46_29 VGND VGND VPWR VPWR sky130_fd_sc_hd__fill_1
X_1368_ _1880_/Q _1377_/B _1367_/Y _1407_/C1 VGND VGND VPWR VPWR _1880_/D sky130_fd_sc_hd__o211a_2
X_1299_ _1299_/A _1327_/B _1327_/C VGND VGND VPWR VPWR _1386_/A sky130_fd_sc_hd__or3_2
XFILLER_23_165 VGND VGND VPWR VPWR sky130_fd_sc_hd__decap_3
XFILLER_46_246 VGND VGND VPWR VPWR sky130_fd_sc_hd__decap_3
XPHY_EDGE_ROW_26_Left_79 VGND VGND VPWR VPWR sky130_fd_sc_hd__decap_3
X_1084_ _2106_/Q _2109_/Q _2112_/Q _2115_/Q _2116_/Q _2117_/Q VGND VGND VPWR VPWR
+ _1085_/A sky130_fd_sc_hd__mux4_2
X_1222_ _1222_/A _1222_/B _1228_/A VGND VGND VPWR VPWR _1222_/X sky130_fd_sc_hd__or3_2
X_1153_ _1153_/A _1153_/B VGND VGND VPWR VPWR _1260_/B sky130_fd_sc_hd__and2_2
X_1986_ _2001_/CLK _1986_/D VGND VGND VPWR VPWR _1986_/Q sky130_fd_sc_hd__dfxtp_2
Xclkbuf_leaf_9_clk clkbuf_leaf_9_clk/A VGND VGND VPWR VPWR _2001_/CLK sky130_fd_sc_hd__clkbuf_8
X_0937_ _2078_/Q _2079_/Q _2080_/Q VGND VGND VPWR VPWR _0938_/B sky130_fd_sc_hd__a21oi_2
XFILLER_9_191 VGND VGND VPWR VPWR sky130_fd_sc_hd__decap_3
XFILLER_36_290 VGND VGND VPWR VPWR sky130_fd_sc_hd__decap_3
XFILLER_28_235 VGND VGND VPWR VPWR sky130_fd_sc_hd__decap_3
XFILLER_11_113 VGND VGND VPWR VPWR sky130_fd_sc_hd__fill_1
XFILLER_19_268 VGND VGND VPWR VPWR sky130_fd_sc_hd__decap_3
X_1840_ _1902_/Q _1840_/B VGND VGND VPWR VPWR _1840_/Y sky130_fd_sc_hd__nand2_2
XFILLER_42_260 VGND VGND VPWR VPWR sky130_fd_sc_hd__fill_1
XTAP_TAPCELL_ROW_29_274 VGND VPWR sky130_fd_sc_hd__tapvpwrvgnd_1
XFILLER_27_290 VGND VGND VPWR VPWR sky130_fd_sc_hd__decap_3
X_1771_ _1816_/A _1506_/A _1789_/B1 _1770_/X VGND VGND VPWR VPWR _2051_/D sky130_fd_sc_hd__o211a_2
XFILLER_8_77 VGND VGND VPWR VPWR sky130_fd_sc_hd__decap_3
XFILLER_8_88 VGND VGND VPWR VPWR sky130_fd_sc_hd__decap_3
XFILLER_40_3 VGND VGND VPWR VPWR sky130_fd_sc_hd__decap_3
X_1136_ _1136_/A _1136_/B _1136_/C VGND VGND VPWR VPWR _1136_/X sky130_fd_sc_hd__or3_2
X_1205_ _1705_/A _1324_/A _1196_/X _1195_/X VGND VGND VPWR VPWR _1255_/A sky130_fd_sc_hd__a211o_2
X_1067_ _1275_/B _1274_/B _1034_/X VGND VGND VPWR VPWR _1256_/B sky130_fd_sc_hd__a21oi_2
XFILLER_18_290 VGND VGND VPWR VPWR sky130_fd_sc_hd__decap_3
X_1969_ _2077_/CLK _1969_/D VGND VGND VPWR VPWR _1969_/Q sky130_fd_sc_hd__dfxtp_2
XFILLER_0_315 VGND VGND VPWR VPWR sky130_fd_sc_hd__decap_3
XTAP_TAPCELL_ROW_3_131 VGND VPWR sky130_fd_sc_hd__tapvpwrvgnd_1
XTAP_TAPCELL_ROW_26_255 VGND VPWR sky130_fd_sc_hd__tapvpwrvgnd_1
XFILLER_33_85 VGND VGND VPWR VPWR sky130_fd_sc_hd__decap_3
XFILLER_33_74 VGND VGND VPWR VPWR sky130_fd_sc_hd__fill_2
XFILLER_39_319 VGND VGND VPWR VPWR sky130_fd_sc_hd__decap_3
XFILLER_3_175 VGND VGND VPWR VPWR sky130_fd_sc_hd__fill_1
X_1823_ _2093_/D _1816_/B _1817_/X VGND VGND VPWR VPWR _1824_/C sky130_fd_sc_hd__a21o_2
XPHY_EDGE_ROW_29_Left_82 VGND VGND VPWR VPWR sky130_fd_sc_hd__decap_3
X_1754_ _2043_/Q _1754_/B VGND VGND VPWR VPWR _1754_/X sky130_fd_sc_hd__or2_2
X_1685_ _2069_/Q _1711_/C _2070_/Q VGND VGND VPWR VPWR _1707_/B sky130_fd_sc_hd__and3b_2
XPHY_EDGE_ROW_13_Left_66 VGND VGND VPWR VPWR sky130_fd_sc_hd__decap_3
X_2099_ clkload9/A _2099_/D VGND VGND VPWR VPWR _2099_/Q sky130_fd_sc_hd__dfxtp_2
XTAP_TAPCELL_ROW_48_380 VGND VPWR sky130_fd_sc_hd__tapvpwrvgnd_1
XTAP_TAPCELL_ROW_0_112 VGND VPWR sky130_fd_sc_hd__tapvpwrvgnd_1
X_1119_ _1965_/Q _1969_/Q _1973_/Q _1977_/Q _1141_/S0 _1141_/S1 VGND VGND VPWR VPWR
+ _1119_/X sky130_fd_sc_hd__mux4_2
XPHY_EDGE_ROW_17_Right_17 VGND VGND VPWR VPWR sky130_fd_sc_hd__decap_3
XPHY_EDGE_ROW_26_Right_26 VGND VGND VPWR VPWR sky130_fd_sc_hd__decap_3
XFILLER_0_134 VGND VGND VPWR VPWR sky130_fd_sc_hd__decap_3
XPHY_EDGE_ROW_35_Right_35 VGND VGND VPWR VPWR sky130_fd_sc_hd__decap_3
X_1470_ _2065_/Q _1500_/A VGND VGND VPWR VPWR _1521_/B sky130_fd_sc_hd__or2_2
XFILLER_8_267 VGND VGND VPWR VPWR sky130_fd_sc_hd__decap_3
XFILLER_8_278 VGND VGND VPWR VPWR sky130_fd_sc_hd__decap_3
XPHY_EDGE_ROW_44_Right_44 VGND VGND VPWR VPWR sky130_fd_sc_hd__decap_3
XFILLER_50_303 VGND VGND VPWR VPWR sky130_fd_sc_hd__decap_3
XTAP_TAPCELL_ROW_45_361 VGND VPWR sky130_fd_sc_hd__tapvpwrvgnd_1
XTAP_TAPCELL_ROW_37_317 VGND VPWR sky130_fd_sc_hd__tapvpwrvgnd_1
XFILLER_35_322 VGND VGND VPWR VPWR sky130_fd_sc_hd__fill_2
X_2022_ _2068_/CLK _2022_/D VGND VGND VPWR VPWR _2022_/Q sky130_fd_sc_hd__dfxtp_2
X_1806_ _1806_/A _2069_/Q VGND VGND VPWR VPWR _1806_/X sky130_fd_sc_hd__or2_2
X_1737_ _2036_/Q _1737_/B VGND VGND VPWR VPWR _1739_/A sky130_fd_sc_hd__and2_2
X_1668_ _1683_/A _1668_/B VGND VGND VPWR VPWR _1668_/Y sky130_fd_sc_hd__nor2_2
X_1599_ _1599_/A _1614_/B VGND VGND VPWR VPWR _1603_/S sky130_fd_sc_hd__nor2_2
XFILLER_38_193 VGND VGND VPWR VPWR sky130_fd_sc_hd__decap_3
XFILLER_17_322 VGND VGND VPWR VPWR sky130_fd_sc_hd__fill_2
XTAP_TAPCELL_ROW_42_342 VGND VPWR sky130_fd_sc_hd__tapvpwrvgnd_1
X_0970_ _2040_/Q _2038_/Q _2039_/Q VGND VGND VPWR VPWR a_selb0[1] sky130_fd_sc_hd__or3b_2
X_1453_ _2102_/Q _0934_/Y _1911_/Q VGND VGND VPWR VPWR _1454_/B sky130_fd_sc_hd__a21o_2
X_1522_ _1620_/B hold194/X _1525_/S VGND VGND VPWR VPWR _1924_/D sky130_fd_sc_hd__mux2_1
X_2005_ clkload5/A _2005_/D VGND VGND VPWR VPWR _2005_/Q sky130_fd_sc_hd__dfxtp_2
X_1384_ _1384_/A _1390_/B VGND VGND VPWR VPWR _1384_/Y sky130_fd_sc_hd__nand2_2
XFILLER_50_188 VGND VGND VPWR VPWR sky130_fd_sc_hd__decap_3
XFILLER_35_141 VGND VGND VPWR VPWR sky130_fd_sc_hd__decap_3
XFILLER_2_218 VGND VGND VPWR VPWR sky130_fd_sc_hd__decap_3
XFILLER_4_9 VGND VGND VPWR VPWR sky130_fd_sc_hd__fill_1
Xdig_top_99 VGND VGND VPWR VPWR dig_top_99/HI uio_oe[5] sky130_fd_sc_hd__conb_1
XFILLER_41_155 VGND VGND VPWR VPWR sky130_fd_sc_hd__decap_3
XFILLER_49_233 VGND VGND VPWR VPWR sky130_fd_sc_hd__fill_1
XFILLER_49_222 VGND VGND VPWR VPWR sky130_fd_sc_hd__fill_2
XFILLER_2_24 VGND VGND VPWR VPWR sky130_fd_sc_hd__decap_3
XFILLER_1_284 VGND VGND VPWR VPWR sky130_fd_sc_hd__fill_2
XFILLER_17_130 VGND VGND VPWR VPWR sky130_fd_sc_hd__decap_3
XFILLER_32_166 VGND VGND VPWR VPWR sky130_fd_sc_hd__decap_3
XFILLER_17_185 VGND VGND VPWR VPWR sky130_fd_sc_hd__fill_1
X_0953_ _2087_/Q _0954_/B VGND VGND VPWR VPWR _0957_/C sky130_fd_sc_hd__and2_2
X_1436_ _1831_/C _1436_/B _1436_/C VGND VGND VPWR VPWR _1905_/D sky130_fd_sc_hd__and3_2
X_1505_ _1506_/A _1598_/A VGND VGND VPWR VPWR _1505_/X sky130_fd_sc_hd__and2_2
X_1367_ _1392_/A _1377_/B VGND VGND VPWR VPWR _1367_/Y sky130_fd_sc_hd__nand2_2
X_1298_ _1852_/Q _1310_/A _1297_/Y _1389_/C1 VGND VGND VPWR VPWR _1852_/D sky130_fd_sc_hd__o211a_2
XFILLER_23_133 VGND VGND VPWR VPWR sky130_fd_sc_hd__fill_2
XFILLER_11_77 VGND VGND VPWR VPWR sky130_fd_sc_hd__decap_3
XFILLER_36_85 VGND VGND VPWR VPWR sky130_fd_sc_hd__fill_2
XFILLER_36_41 VGND VGND VPWR VPWR sky130_fd_sc_hd__fill_1
XPHY_EDGE_ROW_1_Left_54 VGND VGND VPWR VPWR sky130_fd_sc_hd__decap_3
XFILLER_35_6 VGND VGND VPWR VPWR sky130_fd_sc_hd__fill_2
X_1221_ _1208_/B _1220_/Y _1264_/B VGND VGND VPWR VPWR _1221_/X sky130_fd_sc_hd__a21o_2
XFILLER_37_269 VGND VGND VPWR VPWR sky130_fd_sc_hd__decap_3
XFILLER_37_214 VGND VGND VPWR VPWR sky130_fd_sc_hd__fill_1
X_1083_ _1983_/Q _1987_/Q _1991_/Q _1995_/Q _1083_/S0 _1003_/B VGND VGND VPWR VPWR
+ _1083_/X sky130_fd_sc_hd__mux4_2
X_1152_ _1152_/A _1152_/B _1152_/C VGND VGND VPWR VPWR _1153_/B sky130_fd_sc_hd__or3_2
X_1985_ _2065_/CLK _1985_/D VGND VGND VPWR VPWR _1985_/Q sky130_fd_sc_hd__dfxtp_2
X_0936_ _2078_/Q _2079_/Q _2080_/Q VGND VGND VPWR VPWR _0940_/B sky130_fd_sc_hd__and3_2
XTAP_TAPCELL_ROW_15_194 VGND VPWR sky130_fd_sc_hd__tapvpwrvgnd_1
XFILLER_20_103 VGND VGND VPWR VPWR sky130_fd_sc_hd__fill_1
X_1419_ _1902_/Q _1846_/D _1830_/C VGND VGND VPWR VPWR _1419_/Y sky130_fd_sc_hd__a21oi_2
XPHY_EDGE_ROW_43_Left_96 VGND VGND VPWR VPWR sky130_fd_sc_hd__decap_3
XFILLER_28_203 VGND VGND VPWR VPWR sky130_fd_sc_hd__decap_3
XFILLER_11_169 VGND VGND VPWR VPWR sky130_fd_sc_hd__decap_3
XFILLER_22_43 VGND VGND VPWR VPWR sky130_fd_sc_hd__fill_2
XFILLER_22_98 VGND VGND VPWR VPWR sky130_fd_sc_hd__fill_1
XFILLER_0_3 VGND VGND VPWR VPWR sky130_fd_sc_hd__decap_3
XTAP_TAPCELL_ROW_29_275 VGND VPWR sky130_fd_sc_hd__tapvpwrvgnd_1
X_1770_ _1808_/A _1770_/B VGND VGND VPWR VPWR _1770_/X sky130_fd_sc_hd__or2_2
XFILLER_6_195 VGND VGND VPWR VPWR sky130_fd_sc_hd__fill_1
XFILLER_33_3 VGND VGND VPWR VPWR sky130_fd_sc_hd__decap_3
X_1204_ _1705_/A _1324_/A _1195_/X VGND VGND VPWR VPWR _1204_/Y sky130_fd_sc_hd__a21oi_2
X_1135_ _1980_/Q _1137_/A2 _1441_/B _1992_/Q VGND VGND VPWR VPWR _1136_/C sky130_fd_sc_hd__a22o_2
XFILLER_33_261 VGND VGND VPWR VPWR sky130_fd_sc_hd__decap_3
XFILLER_25_228 VGND VGND VPWR VPWR sky130_fd_sc_hd__fill_1
XFILLER_25_217 VGND VGND VPWR VPWR sky130_fd_sc_hd__decap_3
XFILLER_18_280 VGND VGND VPWR VPWR sky130_fd_sc_hd__decap_3
X_1066_ _1079_/A _1181_/A VGND VGND VPWR VPWR _1274_/B sky130_fd_sc_hd__or2_2
X_1899_ _1899_/CLK _1899_/D VGND VGND VPWR VPWR _1899_/Q sky130_fd_sc_hd__dfxtp_2
X_0919_ _1808_/A VGND VGND VPWR VPWR _0919_/Y sky130_fd_sc_hd__inv_2
X_1968_ _2064_/CLK _1968_/D VGND VGND VPWR VPWR _1968_/Q sky130_fd_sc_hd__dfxtp_2
XFILLER_48_309 VGND VGND VPWR VPWR sky130_fd_sc_hd__fill_1
XTAP_TAPCELL_ROW_3_132 VGND VPWR sky130_fd_sc_hd__tapvpwrvgnd_1
XFILLER_16_239 VGND VGND VPWR VPWR sky130_fd_sc_hd__decap_3
XTAP_TAPCELL_ROW_26_256 VGND VPWR sky130_fd_sc_hd__tapvpwrvgnd_1
XFILLER_24_261 VGND VGND VPWR VPWR sky130_fd_sc_hd__decap_3
XFILLER_3_132 VGND VGND VPWR VPWR sky130_fd_sc_hd__decap_3
XFILLER_3_121 VGND VGND VPWR VPWR sky130_fd_sc_hd__decap_3
XFILLER_22_209 VGND VGND VPWR VPWR sky130_fd_sc_hd__decap_3
XFILLER_30_264 VGND VGND VPWR VPWR sky130_fd_sc_hd__fill_2
X_1753_ _2053_/Q _1743_/X _1752_/X _1779_/B1 VGND VGND VPWR VPWR _2042_/D sky130_fd_sc_hd__o211a_2
X_1822_ _1814_/Y _1817_/X _2075_/Q VGND VGND VPWR VPWR _1824_/B sky130_fd_sc_hd__o21bai_2
X_1684_ hold129/X _1676_/X _1683_/Y VGND VGND VPWR VPWR _2011_/D sky130_fd_sc_hd__a21o_2
XFILLER_38_320 VGND VGND VPWR VPWR sky130_fd_sc_hd__decap_3
XTAP_TAPCELL_ROW_0_113 VGND VPWR sky130_fd_sc_hd__tapvpwrvgnd_1
X_2098_ clkload8/A input5/X VGND VGND VPWR VPWR _2098_/Q sky130_fd_sc_hd__dfxtp_2
X_1049_ _1236_/A _1236_/B _1236_/C VGND VGND VPWR VPWR _1245_/B sky130_fd_sc_hd__a21o_2
X_1118_ _1153_/A VGND VGND VPWR VPWR _1118_/Y sky130_fd_sc_hd__inv_2
XFILLER_0_113 VGND VGND VPWR VPWR sky130_fd_sc_hd__decap_3
XFILLER_0_179 VGND VGND VPWR VPWR sky130_fd_sc_hd__decap_3
XFILLER_28_97 VGND VGND VPWR VPWR sky130_fd_sc_hd__decap_3
XFILLER_28_42 VGND VGND VPWR VPWR sky130_fd_sc_hd__fill_2
XFILLER_44_85 VGND VGND VPWR VPWR sky130_fd_sc_hd__fill_1
XPHY_EDGE_ROW_30_Left_83 VGND VGND VPWR VPWR sky130_fd_sc_hd__decap_3
XFILLER_12_253 VGND VGND VPWR VPWR sky130_fd_sc_hd__decap_3
XFILLER_12_286 VGND VGND VPWR VPWR sky130_fd_sc_hd__fill_2
XFILLER_5_57 VGND VGND VPWR VPWR sky130_fd_sc_hd__decap_3
XFILLER_5_24 VGND VGND VPWR VPWR sky130_fd_sc_hd__decap_3
XTAP_TAPCELL_ROW_37_318 VGND VPWR sky130_fd_sc_hd__tapvpwrvgnd_1
X_2021_ clkload1/A _2021_/D VGND VGND VPWR VPWR _2021_/Q sky130_fd_sc_hd__dfxtp_2
XTAP_TAPCELL_ROW_45_362 VGND VPWR sky130_fd_sc_hd__tapvpwrvgnd_1
X_1736_ _1737_/B _1736_/B _1736_/C VGND VGND VPWR VPWR _2035_/D sky130_fd_sc_hd__and3b_2
X_1805_ _1807_/A1 _2067_/Q _1805_/B1 _1804_/X VGND VGND VPWR VPWR _2068_/D sky130_fd_sc_hd__o211a_2
X_1667_ hold142/X _1661_/X _1666_/Y VGND VGND VPWR VPWR _2002_/D sky130_fd_sc_hd__a21o_2
X_1598_ _1598_/A _1598_/B _2063_/Q VGND VGND VPWR VPWR _1614_/B sky130_fd_sc_hd__or3b_2
XFILLER_38_150 VGND VGND VPWR VPWR sky130_fd_sc_hd__decap_3
XFILLER_26_312 VGND VGND VPWR VPWR sky130_fd_sc_hd__decap_3
XFILLER_30_21 VGND VGND VPWR VPWR sky130_fd_sc_hd__decap_3
XFILLER_5_216 VGND VGND VPWR VPWR sky130_fd_sc_hd__fill_1
XFILLER_44_197 VGND VGND VPWR VPWR sky130_fd_sc_hd__decap_3
XFILLER_44_175 VGND VGND VPWR VPWR sky130_fd_sc_hd__fill_1
XTAP_TAPCELL_ROW_42_343 VGND VPWR sky130_fd_sc_hd__tapvpwrvgnd_1
X_1452_ _1846_/C _1457_/A _1452_/C VGND VGND VPWR VPWR _1910_/D sky130_fd_sc_hd__and3_2
X_1383_ _1383_/A _1464_/A VGND VGND VPWR VPWR _1383_/Y sky130_fd_sc_hd__nor2_2
X_1521_ _1521_/A _1521_/B VGND VGND VPWR VPWR _1620_/B sky130_fd_sc_hd__and2_2
XFILLER_4_260 VGND VGND VPWR VPWR sky130_fd_sc_hd__decap_3
X_2004_ _2114_/CLK _2004_/D VGND VGND VPWR VPWR _2004_/Q sky130_fd_sc_hd__dfxtp_2
X_1719_ _2027_/Q _1724_/B _1718_/Y _1749_/C1 VGND VGND VPWR VPWR _2027_/D sky130_fd_sc_hd__o211a_2
XFILLER_26_131 VGND VGND VPWR VPWR sky130_fd_sc_hd__fill_1
XFILLER_25_43 VGND VGND VPWR VPWR sky130_fd_sc_hd__decap_3
XFILLER_14_304 VGND VGND VPWR VPWR sky130_fd_sc_hd__decap_3
XFILLER_41_167 VGND VGND VPWR VPWR sky130_fd_sc_hd__fill_1
XFILLER_41_53 VGND VGND VPWR VPWR sky130_fd_sc_hd__decap_3
X_0952_ _0954_/B _0952_/B VGND VGND VPWR VPWR _2086_/D sky130_fd_sc_hd__nor2_2
XFILLER_20_307 VGND VGND VPWR VPWR sky130_fd_sc_hd__fill_1
X_1504_ _1921_/Q _1514_/B VGND VGND VPWR VPWR _1504_/X sky130_fd_sc_hd__and2_2
X_1435_ _1418_/A _1831_/B _1427_/Y _1433_/Y VGND VGND VPWR VPWR _1436_/C sky130_fd_sc_hd__o211ai_2
X_1366_ _1879_/Q _1365_/B _1365_/Y _1846_/C VGND VGND VPWR VPWR _1879_/D sky130_fd_sc_hd__o211a_2
X_1297_ _1310_/A _1384_/A VGND VGND VPWR VPWR _1297_/Y sky130_fd_sc_hd__nand2_2
XFILLER_52_85 VGND VGND VPWR VPWR sky130_fd_sc_hd__fill_1
XFILLER_6_322 VGND VGND VPWR VPWR sky130_fd_sc_hd__fill_2
X_1220_ _1054_/X _1230_/A _1222_/A VGND VGND VPWR VPWR _1220_/Y sky130_fd_sc_hd__o21ai_2
X_1151_ _1277_/A _1150_/B _1133_/X VGND VGND VPWR VPWR _1260_/A sky130_fd_sc_hd__a21o_2
XFILLER_45_292 VGND VGND VPWR VPWR sky130_fd_sc_hd__fill_1
X_1082_ _1145_/S VGND VGND VPWR VPWR _1082_/Y sky130_fd_sc_hd__inv_2
X_1984_ _2065_/CLK _1984_/D VGND VGND VPWR VPWR _1984_/Q sky130_fd_sc_hd__dfxtp_2
X_0935_ _2078_/Q _2079_/Q VGND VGND VPWR VPWR _2079_/D sky130_fd_sc_hd__xor2_2
XFILLER_9_182 VGND VGND VPWR VPWR sky130_fd_sc_hd__decap_3
XTAP_TAPCELL_ROW_15_195 VGND VPWR sky130_fd_sc_hd__tapvpwrvgnd_1
X_1418_ _1418_/A _1831_/B VGND VGND VPWR VPWR _1846_/D sky130_fd_sc_hd__or2_2
XFILLER_28_226 VGND VGND VPWR VPWR sky130_fd_sc_hd__decap_3
X_1349_ _1871_/Q _1352_/B _1348_/Y _1395_/C1 VGND VGND VPWR VPWR _1871_/D sky130_fd_sc_hd__o211a_2
XFILLER_36_281 VGND VGND VPWR VPWR sky130_fd_sc_hd__decap_3
XFILLER_7_119 VGND VGND VPWR VPWR sky130_fd_sc_hd__fill_1
XFILLER_27_281 VGND VGND VPWR VPWR sky130_fd_sc_hd__decap_3
XFILLER_27_270 VGND VGND VPWR VPWR sky130_fd_sc_hd__fill_1
Xdig_top_100 VGND VGND VPWR VPWR dig_top_100/HI uio_oe[6] sky130_fd_sc_hd__conb_1
XFILLER_8_24 VGND VGND VPWR VPWR sky130_fd_sc_hd__decap_3
XFILLER_8_35 VGND VGND VPWR VPWR sky130_fd_sc_hd__decap_3
XFILLER_10_170 VGND VGND VPWR VPWR sky130_fd_sc_hd__decap_3
XFILLER_6_174 VGND VGND VPWR VPWR sky130_fd_sc_hd__decap_3
X_1134_ _1984_/Q _1138_/A2 _1138_/B1 _1988_/Q VGND VGND VPWR VPWR _1136_/B sky130_fd_sc_hd__a22o_2
X_1203_ _1266_/B1 _1202_/X _1199_/X VGND VGND VPWR VPWR _1324_/A sky130_fd_sc_hd__a21oi_2
XFILLER_33_273 VGND VGND VPWR VPWR sky130_fd_sc_hd__fill_2
X_1065_ _1061_/X _1100_/A _1064_/A VGND VGND VPWR VPWR _1228_/B sky130_fd_sc_hd__a21o_2
X_1898_ _1899_/CLK _1898_/D VGND VGND VPWR VPWR _1898_/Q sky130_fd_sc_hd__dfxtp_2
X_0918_ _2076_/Q VGND VGND VPWR VPWR _1483_/A sky130_fd_sc_hd__inv_2
X_1967_ _2077_/CLK _1967_/D VGND VGND VPWR VPWR _1967_/Q sky130_fd_sc_hd__dfxtp_2
XFILLER_0_306 VGND VGND VPWR VPWR sky130_fd_sc_hd__fill_2
XFILLER_17_66 VGND VGND VPWR VPWR sky130_fd_sc_hd__fill_1
XFILLER_33_98 VGND VGND VPWR VPWR sky130_fd_sc_hd__decap_3
XTAP_TAPCELL_ROW_26_257 VGND VPWR sky130_fd_sc_hd__tapvpwrvgnd_1
XFILLER_3_111 VGND VGND VPWR VPWR sky130_fd_sc_hd__fill_1
XFILLER_15_295 VGND VGND VPWR VPWR sky130_fd_sc_hd__decap_3
X_1683_ _1683_/A _1683_/B VGND VGND VPWR VPWR _1683_/Y sky130_fd_sc_hd__nor2_2
Xclkbuf_leaf_10_clk clkbuf_2_2__f_clk/X VGND VGND VPWR VPWR clkload5/A sky130_fd_sc_hd__clkbuf_8
X_1752_ _2042_/Q _1754_/B VGND VGND VPWR VPWR _1752_/X sky130_fd_sc_hd__or2_2
X_1821_ _1824_/A _1821_/B VGND VGND VPWR VPWR _2074_/D sky130_fd_sc_hd__and2_2
X_2097_ clkload9/A _2097_/D VGND VGND VPWR VPWR _2097_/Q sky130_fd_sc_hd__dfxtp_2
X_1117_ _1152_/B _1152_/C _1152_/A VGND VGND VPWR VPWR _1153_/A sky130_fd_sc_hd__o21ai_2
XTAP_TAPCELL_ROW_0_114 VGND VPWR sky130_fd_sc_hd__tapvpwrvgnd_1
XTAP_TAPCELL_ROW_23_238 VGND VPWR sky130_fd_sc_hd__tapvpwrvgnd_1
X_1048_ _1245_/A _1048_/B VGND VGND VPWR VPWR _1236_/C sky130_fd_sc_hd__nand2_2
XPHY_EDGE_ROW_3_Right_3 VGND VGND VPWR VPWR sky130_fd_sc_hd__decap_3
XFILLER_21_287 VGND VGND VPWR VPWR sky130_fd_sc_hd__decap_3
XTAP_TAPCELL_ROW_31_282 VGND VPWR sky130_fd_sc_hd__tapvpwrvgnd_1
XFILLER_28_65 VGND VGND VPWR VPWR sky130_fd_sc_hd__fill_2
XFILLER_28_32 VGND VGND VPWR VPWR sky130_fd_sc_hd__fill_1
XFILLER_28_21 VGND VGND VPWR VPWR sky130_fd_sc_hd__decap_3
XFILLER_0_125 VGND VGND VPWR VPWR sky130_fd_sc_hd__fill_1
XFILLER_0_147 VGND VGND VPWR VPWR sky130_fd_sc_hd__fill_1
XFILLER_0_169 VGND VGND VPWR VPWR sky130_fd_sc_hd__decap_3
XFILLER_8_258 VGND VGND VPWR VPWR sky130_fd_sc_hd__fill_2
XFILLER_12_232 VGND VGND VPWR VPWR sky130_fd_sc_hd__decap_3
XTAP_TAPCELL_ROW_37_319 VGND VPWR sky130_fd_sc_hd__tapvpwrvgnd_1
X_2020_ clkload1/A _2020_/D VGND VGND VPWR VPWR _2020_/Q sky130_fd_sc_hd__dfxtp_2
XTAP_TAPCELL_ROW_45_363 VGND VPWR sky130_fd_sc_hd__tapvpwrvgnd_1
X_1735_ _2034_/Q _2035_/Q _1735_/C VGND VGND VPWR VPWR _1737_/B sky130_fd_sc_hd__and3_2
X_1666_ _1681_/A _1668_/B VGND VGND VPWR VPWR _1666_/Y sky130_fd_sc_hd__nor2_2
X_1804_ _2093_/D _2068_/Q VGND VGND VPWR VPWR _1804_/X sky130_fd_sc_hd__or2_2
X_1597_ hold131/X _2052_/Q _1597_/S VGND VGND VPWR VPWR _1963_/D sky130_fd_sc_hd__mux2_1
XFILLER_38_162 VGND VGND VPWR VPWR sky130_fd_sc_hd__fill_2
XFILLER_26_302 VGND VGND VPWR VPWR sky130_fd_sc_hd__decap_3
XFILLER_14_78 VGND VGND VPWR VPWR sky130_fd_sc_hd__fill_1
XFILLER_30_99 VGND VGND VPWR VPWR sky130_fd_sc_hd__decap_3
XFILLER_30_88 VGND VGND VPWR VPWR sky130_fd_sc_hd__fill_1
XTAP_TAPCELL_ROW_42_344 VGND VPWR sky130_fd_sc_hd__tapvpwrvgnd_1
X_1520_ _1796_/B _1598_/B _1588_/A VGND VGND VPWR VPWR _1525_/S sky130_fd_sc_hd__or3_2
X_1451_ _1003_/B _1908_/Q _1907_/Q _1442_/Y VGND VGND VPWR VPWR _1452_/C sky130_fd_sc_hd__a31o_2
X_1382_ _1383_/A _1462_/A _1187_/Y _1381_/X _1407_/C1 VGND VGND VPWR VPWR _1887_/D
+ sky130_fd_sc_hd__o311a_2
XFILLER_4_283 VGND VGND VPWR VPWR sky130_fd_sc_hd__decap_3
XFILLER_4_272 VGND VGND VPWR VPWR sky130_fd_sc_hd__decap_3
X_2003_ _2036_/CLK _2003_/D VGND VGND VPWR VPWR _2003_/Q sky130_fd_sc_hd__dfxtp_2
XFILLER_35_165 VGND VGND VPWR VPWR sky130_fd_sc_hd__decap_3
XFILLER_50_135 VGND VGND VPWR VPWR sky130_fd_sc_hd__fill_1
X_1649_ _1679_/A _1653_/B VGND VGND VPWR VPWR _1649_/Y sky130_fd_sc_hd__nor2_2
X_1718_ _1772_/B _1724_/B VGND VGND VPWR VPWR _1718_/Y sky130_fd_sc_hd__nand2b_2
XFILLER_41_113 VGND VGND VPWR VPWR sky130_fd_sc_hd__decap_3
XFILLER_25_55 VGND VGND VPWR VPWR sky130_fd_sc_hd__fill_1
XFILLER_1_242 VGND VGND VPWR VPWR sky130_fd_sc_hd__fill_2
X_0951_ _2085_/Q _0950_/C _2086_/Q VGND VGND VPWR VPWR _0952_/B sky130_fd_sc_hd__a21oi_2
XFILLER_9_320 VGND VGND VPWR VPWR sky130_fd_sc_hd__decap_3
X_1503_ _1518_/A1 _1497_/A _1501_/X _1498_/X VGND VGND VPWR VPWR _1920_/D sky130_fd_sc_hd__a31o_2
X_1434_ _1846_/D _1427_/Y _1433_/Y VGND VGND VPWR VPWR _1436_/B sky130_fd_sc_hd__a21o_2
X_1296_ _1296_/A _1327_/B _1327_/C VGND VGND VPWR VPWR _1384_/A sky130_fd_sc_hd__or3_2
X_1365_ _1390_/A _1365_/B VGND VGND VPWR VPWR _1365_/Y sky130_fd_sc_hd__nand2_2
XFILLER_46_249 VGND VGND VPWR VPWR sky130_fd_sc_hd__decap_3
XFILLER_46_205 VGND VGND VPWR VPWR sky130_fd_sc_hd__decap_3
XFILLER_52_42 VGND VGND VPWR VPWR sky130_fd_sc_hd__fill_1
XFILLER_22_190 VGND VGND VPWR VPWR sky130_fd_sc_hd__decap_3
XTAP_TAPCELL_ROW_9_161 VGND VPWR sky130_fd_sc_hd__tapvpwrvgnd_1
X_1150_ _1133_/X _1150_/B VGND VGND VPWR VPWR _1277_/B sky130_fd_sc_hd__and2b_2
X_1081_ _2104_/Q _2107_/Q _2110_/Q _2113_/Q _2116_/Q _2117_/Q VGND VGND VPWR VPWR
+ _1136_/A sky130_fd_sc_hd__mux4_2
X_0934_ _2103_/Q VGND VGND VPWR VPWR _0934_/Y sky130_fd_sc_hd__inv_2
X_1983_ _2065_/CLK _1983_/D VGND VGND VPWR VPWR _1983_/Q sky130_fd_sc_hd__dfxtp_2
XFILLER_9_194 VGND VGND VPWR VPWR sky130_fd_sc_hd__decap_3
XTAP_TAPCELL_ROW_15_196 VGND VPWR sky130_fd_sc_hd__tapvpwrvgnd_1
X_1417_ _1418_/A _1831_/B VGND VGND VPWR VPWR _1830_/D sky130_fd_sc_hd__nor2_2
XFILLER_28_238 VGND VGND VPWR VPWR sky130_fd_sc_hd__decap_3
X_1348_ _1398_/A _1352_/B VGND VGND VPWR VPWR _1348_/Y sky130_fd_sc_hd__nand2_2
X_1279_ _1279_/A1 _1278_/X _1276_/X VGND VGND VPWR VPWR _1299_/A sky130_fd_sc_hd__a21o_2
XFILLER_36_293 VGND VGND VPWR VPWR sky130_fd_sc_hd__fill_1
XFILLER_27_293 VGND VGND VPWR VPWR sky130_fd_sc_hd__fill_2
Xdig_top_101 VGND VGND VPWR VPWR dig_top_101/HI uio_oe[7] sky130_fd_sc_hd__conb_1
XTAP_TAPCELL_ROW_12_177 VGND VPWR sky130_fd_sc_hd__tapvpwrvgnd_1
XFILLER_40_6 VGND VGND VPWR VPWR sky130_fd_sc_hd__decap_3
XFILLER_6_197 VGND VGND VPWR VPWR sky130_fd_sc_hd__decap_3
X_1133_ _1149_/B _1149_/C _1149_/A VGND VGND VPWR VPWR _1133_/X sky130_fd_sc_hd__o21a_2
X_1202_ _1211_/A1 _1061_/X _1201_/Y _1200_/X _1264_/B VGND VGND VPWR VPWR _1202_/X
+ sky130_fd_sc_hd__o32a_2
X_1064_ _1064_/A _1100_/A VGND VGND VPWR VPWR _1064_/X sky130_fd_sc_hd__or2_2
XFILLER_19_3 VGND VGND VPWR VPWR sky130_fd_sc_hd__decap_3
XFILLER_18_271 VGND VGND VPWR VPWR sky130_fd_sc_hd__fill_1
XFILLER_18_293 VGND VGND VPWR VPWR sky130_fd_sc_hd__fill_2
X_1966_ clkload0/A _1966_/D VGND VGND VPWR VPWR _1966_/Q sky130_fd_sc_hd__dfxtp_2
X_1897_ _1897_/CLK _1897_/D VGND VGND VPWR VPWR _1897_/Q sky130_fd_sc_hd__dfxtp_2
XFILLER_0_318 VGND VGND VPWR VPWR sky130_fd_sc_hd__decap_3
XTAP_TAPCELL_ROW_26_258 VGND VPWR sky130_fd_sc_hd__tapvpwrvgnd_1
X_1820_ _2093_/D _1483_/C _1814_/Y _1817_/X _2074_/Q VGND VGND VPWR VPWR _1821_/B
+ sky130_fd_sc_hd__a32o_2
XFILLER_15_241 VGND VGND VPWR VPWR sky130_fd_sc_hd__decap_3
X_1682_ hold117/X _1676_/X _1681_/Y VGND VGND VPWR VPWR _2010_/D sky130_fd_sc_hd__a21o_2
XFILLER_30_299 VGND VGND VPWR VPWR sky130_fd_sc_hd__decap_3
X_1751_ _1772_/B _1764_/B _1750_/X _1789_/B1 VGND VGND VPWR VPWR _2041_/D sky130_fd_sc_hd__o211a_2
X_2096_ clkload8/A input4/X VGND VGND VPWR VPWR _2096_/Q sky130_fd_sc_hd__dfxtp_2
X_1116_ _1147_/A _1116_/B VGND VGND VPWR VPWR _1152_/C sky130_fd_sc_hd__and2_2
X_1047_ _2028_/Q _1102_/A VGND VGND VPWR VPWR _1048_/B sky130_fd_sc_hd__or2_2
XTAP_TAPCELL_ROW_0_115 VGND VPWR sky130_fd_sc_hd__tapvpwrvgnd_1
XFILLER_0_92 VGND VGND VPWR VPWR sky130_fd_sc_hd__decap_3
XTAP_TAPCELL_ROW_31_283 VGND VPWR sky130_fd_sc_hd__tapvpwrvgnd_1
X_1949_ _1963_/CLK _1949_/D VGND VGND VPWR VPWR _1949_/Q sky130_fd_sc_hd__dfxtp_2
XTAP_TAPCELL_ROW_23_239 VGND VPWR sky130_fd_sc_hd__tapvpwrvgnd_1
XFILLER_21_244 VGND VGND VPWR VPWR sky130_fd_sc_hd__fill_2
XFILLER_21_299 VGND VGND VPWR VPWR sky130_fd_sc_hd__fill_1
XFILLER_0_104 VGND VGND VPWR VPWR sky130_fd_sc_hd__decap_3
XFILLER_0_137 VGND VGND VPWR VPWR sky130_fd_sc_hd__decap_3
XFILLER_12_211 VGND VGND VPWR VPWR sky130_fd_sc_hd__decap_3
XFILLER_8_215 VGND VGND VPWR VPWR sky130_fd_sc_hd__decap_3
XFILLER_8_237 VGND VGND VPWR VPWR sky130_fd_sc_hd__fill_2
XFILLER_50_306 VGND VGND VPWR VPWR sky130_fd_sc_hd__fill_2
XPHY_EDGE_ROW_13_Right_13 VGND VGND VPWR VPWR sky130_fd_sc_hd__decap_3
XPHY_EDGE_ROW_22_Right_22 VGND VGND VPWR VPWR sky130_fd_sc_hd__decap_3
X_1803_ _1807_/A1 _2066_/Q _1805_/B1 _1802_/X VGND VGND VPWR VPWR _2067_/D sky130_fd_sc_hd__o211a_2
X_1734_ _2034_/Q _1735_/C _2035_/Q VGND VGND VPWR VPWR _1736_/C sky130_fd_sc_hd__a21o_2
X_1665_ _2001_/Q _1661_/X _1664_/Y VGND VGND VPWR VPWR _2001_/D sky130_fd_sc_hd__a21o_2
X_1596_ hold144/X _2051_/Q _1597_/S VGND VGND VPWR VPWR _1962_/D sky130_fd_sc_hd__mux2_1
XFILLER_38_141 VGND VGND VPWR VPWR sky130_fd_sc_hd__decap_3
XPHY_EDGE_ROW_31_Right_31 VGND VGND VPWR VPWR sky130_fd_sc_hd__decap_3
X_2079_ fanout93/X _2079_/D osc_en VGND VGND VPWR VPWR _2079_/Q sky130_fd_sc_hd__dfrtp_2
XPHY_EDGE_ROW_40_Right_40 VGND VGND VPWR VPWR sky130_fd_sc_hd__decap_3
XTAP_TAPCELL_ROW_42_345 VGND VPWR sky130_fd_sc_hd__tapvpwrvgnd_1
XFILLER_32_317 VGND VGND VPWR VPWR sky130_fd_sc_hd__decap_3
X_1450_ _0995_/Y _1449_/X _1831_/C VGND VGND VPWR VPWR _1909_/D sky130_fd_sc_hd__o21a_2
X_1381_ _1887_/Q _1381_/B VGND VGND VPWR VPWR _1381_/X sky130_fd_sc_hd__or2_2
X_2002_ clkload4/A _2002_/D VGND VGND VPWR VPWR _2002_/Q sky130_fd_sc_hd__dfxtp_2
XFILLER_35_144 VGND VGND VPWR VPWR sky130_fd_sc_hd__fill_1
XFILLER_50_158 VGND VGND VPWR VPWR sky130_fd_sc_hd__fill_2
X_1648_ hold176/X _1646_/X _1647_/Y VGND VGND VPWR VPWR _1992_/D sky130_fd_sc_hd__a21o_2
X_1579_ _1951_/Q _1579_/B VGND VGND VPWR VPWR _1579_/X sky130_fd_sc_hd__and2_2
X_1717_ _2026_/Q _1724_/B _1716_/Y _1749_/C1 VGND VGND VPWR VPWR _2026_/D sky130_fd_sc_hd__o211a_2
XFILLER_41_169 VGND VGND VPWR VPWR sky130_fd_sc_hd__decap_3
XFILLER_41_158 VGND VGND VPWR VPWR sky130_fd_sc_hd__decap_3
XFILLER_41_66 VGND VGND VPWR VPWR sky130_fd_sc_hd__fill_2
XFILLER_41_33 VGND VGND VPWR VPWR sky130_fd_sc_hd__fill_2
XFILLER_2_27 VGND VGND VPWR VPWR sky130_fd_sc_hd__fill_1
XFILLER_1_265 VGND VGND VPWR VPWR sky130_fd_sc_hd__fill_2
XFILLER_17_133 VGND VGND VPWR VPWR sky130_fd_sc_hd__fill_1
XFILLER_17_199 VGND VGND VPWR VPWR sky130_fd_sc_hd__decap_3
X_0950_ _2085_/Q _2086_/Q _0950_/C VGND VGND VPWR VPWR _0954_/B sky130_fd_sc_hd__and3_2
XFILLER_20_309 VGND VGND VPWR VPWR sky130_fd_sc_hd__fill_2
X_1433_ _1433_/A VGND VGND VPWR VPWR _1433_/Y sky130_fd_sc_hd__inv_2
X_1502_ _1521_/A _1598_/A VGND VGND VPWR VPWR _1677_/A sky130_fd_sc_hd__nand2_2
X_1364_ _1878_/Q _1365_/B _1363_/Y _1389_/C1 VGND VGND VPWR VPWR _1878_/D sky130_fd_sc_hd__o211a_2
X_1295_ _1327_/B _1327_/C VGND VGND VPWR VPWR _1324_/B sky130_fd_sc_hd__nor2_2
XFILLER_23_169 VGND VGND VPWR VPWR sky130_fd_sc_hd__fill_1
XPHY_EDGE_ROW_52_Left_105 VGND VGND VPWR VPWR sky130_fd_sc_hd__decap_3
XFILLER_31_191 VGND VGND VPWR VPWR sky130_fd_sc_hd__decap_3
XFILLER_14_158 VGND VGND VPWR VPWR sky130_fd_sc_hd__fill_1
XTAP_TAPCELL_ROW_9_162 VGND VPWR sky130_fd_sc_hd__tapvpwrvgnd_1
XFILLER_37_206 VGND VGND VPWR VPWR sky130_fd_sc_hd__decap_3
X_1080_ _1228_/B _1257_/B _1079_/Y _1274_/B VGND VGND VPWR VPWR _1080_/X sky130_fd_sc_hd__a22o_2
X_1982_ clkload5/A _1982_/D VGND VGND VPWR VPWR _1982_/Q sky130_fd_sc_hd__dfxtp_2
X_0933_ _2078_/Q VGND VGND VPWR VPWR _2078_/D sky130_fd_sc_hd__inv_2
XTAP_TAPCELL_ROW_15_197 VGND VPWR sky130_fd_sc_hd__tapvpwrvgnd_1
X_1416_ _1416_/A VGND VGND VPWR VPWR _1831_/B sky130_fd_sc_hd__inv_2
X_1347_ _1870_/Q _1352_/B _1346_/Y _1407_/C1 VGND VGND VPWR VPWR _1870_/D sky130_fd_sc_hd__o211a_2
XFILLER_36_272 VGND VGND VPWR VPWR sky130_fd_sc_hd__fill_1
XFILLER_28_206 VGND VGND VPWR VPWR sky130_fd_sc_hd__decap_3
X_1278_ _1180_/A _1180_/B _1180_/C _1277_/Y VGND VGND VPWR VPWR _1278_/X sky130_fd_sc_hd__a31o_2
XPHY_EDGE_ROW_5_Left_58 VGND VGND VPWR VPWR sky130_fd_sc_hd__decap_3
XFILLER_3_316 VGND VGND VPWR VPWR sky130_fd_sc_hd__decap_3
XFILLER_0_6 VGND VGND VPWR VPWR sky130_fd_sc_hd__decap_3
XFILLER_19_217 VGND VGND VPWR VPWR sky130_fd_sc_hd__decap_3
XFILLER_19_239 VGND VGND VPWR VPWR sky130_fd_sc_hd__decap_3
Xdig_top_102 VGND VGND VPWR VPWR dig_top_102/HI uio_out[0] sky130_fd_sc_hd__conb_1
XFILLER_42_275 VGND VGND VPWR VPWR sky130_fd_sc_hd__decap_3
XTAP_TAPCELL_ROW_12_178 VGND VPWR sky130_fd_sc_hd__tapvpwrvgnd_1
XFILLER_33_6 VGND VGND VPWR VPWR sky130_fd_sc_hd__fill_2
X_1201_ _1201_/A _1201_/B VGND VGND VPWR VPWR _1201_/Y sky130_fd_sc_hd__nor2_2
X_1063_ _1862_/Q _1371_/A1 _1337_/B2 _1898_/Q _1062_/X VGND VGND VPWR VPWR _1100_/A
+ sky130_fd_sc_hd__a221o_2
X_1132_ _1130_/X _1131_/X _1087_/Y _1129_/X VGND VGND VPWR VPWR _1149_/C sky130_fd_sc_hd__o211a_2
XFILLER_18_250 VGND VGND VPWR VPWR sky130_fd_sc_hd__fill_2
XFILLER_18_283 VGND VGND VPWR VPWR sky130_fd_sc_hd__decap_3
XFILLER_33_264 VGND VGND VPWR VPWR sky130_fd_sc_hd__fill_1
X_1965_ _2077_/CLK _1965_/D VGND VGND VPWR VPWR _1965_/Q sky130_fd_sc_hd__dfxtp_2
X_1896_ _1897_/CLK _1896_/D VGND VGND VPWR VPWR _1896_/Q sky130_fd_sc_hd__dfxtp_2
XTAP_TAPCELL_ROW_26_259 VGND VPWR sky130_fd_sc_hd__tapvpwrvgnd_1
XFILLER_24_264 VGND VGND VPWR VPWR sky130_fd_sc_hd__fill_1
XFILLER_30_289 VGND VGND VPWR VPWR sky130_fd_sc_hd__fill_2
X_1750_ _2041_/Q _1760_/B VGND VGND VPWR VPWR _1750_/X sky130_fd_sc_hd__or2_2
XFILLER_15_253 VGND VGND VPWR VPWR sky130_fd_sc_hd__decap_3
X_1681_ _1681_/A _1683_/B VGND VGND VPWR VPWR _1681_/Y sky130_fd_sc_hd__nor2_2
XFILLER_38_323 VGND VGND VPWR VPWR sky130_fd_sc_hd__fill_1
XFILLER_31_3 VGND VGND VPWR VPWR sky130_fd_sc_hd__decap_3
X_2095_ clkload4/A _2095_/D VGND VGND VPWR VPWR _2095_/Q sky130_fd_sc_hd__dfxtp_2
X_1115_ _1111_/X _1114_/X _1146_/S VGND VGND VPWR VPWR _1116_/B sky130_fd_sc_hd__mux2_1
X_1046_ _2028_/Q _1102_/A VGND VGND VPWR VPWR _1046_/X sky130_fd_sc_hd__and2b_2
XTAP_TAPCELL_ROW_0_116 VGND VPWR sky130_fd_sc_hd__tapvpwrvgnd_1
XTAP_TAPCELL_ROW_31_284 VGND VPWR sky130_fd_sc_hd__tapvpwrvgnd_1
X_1879_ _1899_/CLK _1879_/D VGND VGND VPWR VPWR _1879_/Q sky130_fd_sc_hd__dfxtp_2
X_1948_ _2064_/CLK _1948_/D VGND VGND VPWR VPWR _1948_/Q sky130_fd_sc_hd__dfxtp_2
XFILLER_21_256 VGND VGND VPWR VPWR sky130_fd_sc_hd__decap_3
XFILLER_0_116 VGND VGND VPWR VPWR sky130_fd_sc_hd__decap_3
XFILLER_44_99 VGND VGND VPWR VPWR sky130_fd_sc_hd__decap_3
XFILLER_12_256 VGND VGND VPWR VPWR sky130_fd_sc_hd__fill_1
XFILLER_5_49 VGND VGND VPWR VPWR sky130_fd_sc_hd__fill_2
XFILLER_5_27 VGND VGND VPWR VPWR sky130_fd_sc_hd__fill_1
XPHY_EDGE_ROW_8_Left_61 VGND VGND VPWR VPWR sky130_fd_sc_hd__decap_3
Xclkbuf_2_3__f_clk clkbuf_0_clk/X VGND VGND VPWR VPWR clkbuf_leaf_3_clk/A sky130_fd_sc_hd__clkbuf_16
X_1733_ hold167/X _1735_/C _1732_/Y VGND VGND VPWR VPWR _2034_/D sky130_fd_sc_hd__a21oi_2
X_1802_ _1806_/A _2067_/Q VGND VGND VPWR VPWR _1802_/X sky130_fd_sc_hd__or2_2
X_1664_ _1679_/A _1668_/B VGND VGND VPWR VPWR _1664_/Y sky130_fd_sc_hd__nor2_2
X_1595_ hold149/X _2050_/Q _1597_/S VGND VGND VPWR VPWR _1961_/D sky130_fd_sc_hd__mux2_1
XFILLER_7_271 VGND VGND VPWR VPWR sky130_fd_sc_hd__decap_3
XFILLER_38_153 VGND VGND VPWR VPWR sky130_fd_sc_hd__fill_1
XTAP_TAPCELL_ROW_36_310 VGND VPWR sky130_fd_sc_hd__tapvpwrvgnd_1
XFILLER_26_315 VGND VGND VPWR VPWR sky130_fd_sc_hd__decap_3
X_1029_ _1029_/A _1029_/B _1029_/C _1029_/D VGND VGND VPWR VPWR _1152_/A sky130_fd_sc_hd__or4_2
X_2078_ fanout93/X _2078_/D _1756_/A VGND VGND VPWR VPWR _2078_/Q sky130_fd_sc_hd__dfrtp_2
XFILLER_30_24 VGND VGND VPWR VPWR sky130_fd_sc_hd__decap_3
XFILLER_39_99 VGND VGND VPWR VPWR sky130_fd_sc_hd__fill_1
XPHY_EDGE_ROW_34_Left_87 VGND VGND VPWR VPWR sky130_fd_sc_hd__decap_3
XFILLER_32_307 VGND VGND VPWR VPWR sky130_fd_sc_hd__fill_1
XTAP_TAPCELL_ROW_50_390 VGND VPWR sky130_fd_sc_hd__tapvpwrvgnd_1
XTAP_TAPCELL_ROW_42_346 VGND VPWR sky130_fd_sc_hd__tapvpwrvgnd_1
X_1380_ _1886_/Q _1381_/B _1379_/Y _1407_/C1 VGND VGND VPWR VPWR _1886_/D sky130_fd_sc_hd__o211a_2
XFILLER_4_263 VGND VGND VPWR VPWR sky130_fd_sc_hd__decap_3
XFILLER_4_241 VGND VGND VPWR VPWR sky130_fd_sc_hd__decap_3
XFILLER_4_230 VGND VGND VPWR VPWR sky130_fd_sc_hd__decap_3
X_2001_ _2001_/CLK _2001_/D VGND VGND VPWR VPWR _2001_/Q sky130_fd_sc_hd__dfxtp_2
X_1716_ _1770_/B _1724_/B VGND VGND VPWR VPWR _1716_/Y sky130_fd_sc_hd__nand2b_2
X_1647_ _1677_/A _1653_/B VGND VGND VPWR VPWR _1647_/Y sky130_fd_sc_hd__nor2_2
X_1578_ _1626_/A _1497_/A _1510_/X _1577_/X VGND VGND VPWR VPWR _1950_/D sky130_fd_sc_hd__a31o_2
XFILLER_6_81 VGND VGND VPWR VPWR sky130_fd_sc_hd__decap_3
XFILLER_41_104 VGND VGND VPWR VPWR sky130_fd_sc_hd__decap_3
XFILLER_14_307 VGND VGND VPWR VPWR sky130_fd_sc_hd__fill_1
XFILLER_14_318 VGND VGND VPWR VPWR sky130_fd_sc_hd__decap_3
XFILLER_25_57 VGND VGND VPWR VPWR sky130_fd_sc_hd__fill_1
XFILLER_9_3 VGND VGND VPWR VPWR sky130_fd_sc_hd__decap_3
XFILLER_2_39 VGND VGND VPWR VPWR sky130_fd_sc_hd__decap_3
X_1432_ _1432_/A _1432_/B VGND VGND VPWR VPWR _1433_/A sky130_fd_sc_hd__nand2_2
X_1501_ _1521_/A _1598_/A VGND VGND VPWR VPWR _1501_/X sky130_fd_sc_hd__and2_2
X_1363_ _1388_/A _1365_/B VGND VGND VPWR VPWR _1363_/Y sky130_fd_sc_hd__nand2_2
XFILLER_48_270 VGND VGND VPWR VPWR sky130_fd_sc_hd__fill_2
X_1294_ _1255_/X _1294_/B _1294_/C _1294_/D VGND VGND VPWR VPWR _1294_/X sky130_fd_sc_hd__and4b_2
XFILLER_39_292 VGND VGND VPWR VPWR sky130_fd_sc_hd__fill_2
XFILLER_14_137 VGND VGND VPWR VPWR sky130_fd_sc_hd__decap_3
XTAP_TAPCELL_ROW_9_163 VGND VPWR sky130_fd_sc_hd__tapvpwrvgnd_1
XPHY_EDGE_ROW_37_Left_90 VGND VGND VPWR VPWR sky130_fd_sc_hd__decap_3
X_1981_ clkload5/A _1981_/D VGND VGND VPWR VPWR _1981_/Q sky130_fd_sc_hd__dfxtp_2
XTAP_TAPCELL_ROW_15_198 VGND VPWR sky130_fd_sc_hd__tapvpwrvgnd_1
X_0932_ _1824_/A VGND VGND VPWR VPWR _1830_/C sky130_fd_sc_hd__inv_2
XFILLER_9_185 VGND VGND VPWR VPWR sky130_fd_sc_hd__decap_3
XPHY_EDGE_ROW_21_Left_74 VGND VGND VPWR VPWR sky130_fd_sc_hd__decap_3
X_1415_ _1906_/Q _2100_/Q _2099_/Q VGND VGND VPWR VPWR _1416_/A sky130_fd_sc_hd__or3b_2
X_1346_ _1396_/A _1352_/B VGND VGND VPWR VPWR _1346_/Y sky130_fd_sc_hd__nand2_2
XFILLER_28_229 VGND VGND VPWR VPWR sky130_fd_sc_hd__decap_3
XFILLER_36_284 VGND VGND VPWR VPWR sky130_fd_sc_hd__decap_3
X_1277_ _1277_/A _1277_/B VGND VGND VPWR VPWR _1277_/Y sky130_fd_sc_hd__xnor2_2
XFILLER_51_276 VGND VGND VPWR VPWR sky130_fd_sc_hd__decap_3
XTAP_TAPCELL_ROW_6_144 VGND VPWR sky130_fd_sc_hd__tapvpwrvgnd_1
Xdig_top_103 VGND VGND VPWR VPWR dig_top_103/HI uio_out[1] sky130_fd_sc_hd__conb_1
XFILLER_27_284 VGND VGND VPWR VPWR sky130_fd_sc_hd__decap_3
Xclkbuf_leaf_22_clk clkbuf_leaf_2_clk/A VGND VGND VPWR VPWR _2058_/CLK sky130_fd_sc_hd__clkbuf_8
XFILLER_8_27 VGND VGND VPWR VPWR sky130_fd_sc_hd__fill_1
XFILLER_6_111 VGND VGND VPWR VPWR sky130_fd_sc_hd__fill_1
XFILLER_6_133 VGND VGND VPWR VPWR sky130_fd_sc_hd__decap_3
XFILLER_6_177 VGND VGND VPWR VPWR sky130_fd_sc_hd__fill_2
XFILLER_10_151 VGND VGND VPWR VPWR sky130_fd_sc_hd__fill_2
XFILLER_10_195 VGND VGND VPWR VPWR sky130_fd_sc_hd__fill_1
XTAP_TAPCELL_ROW_12_179 VGND VPWR sky130_fd_sc_hd__tapvpwrvgnd_1
X_1200_ _1201_/A _1200_/B VGND VGND VPWR VPWR _1200_/X sky130_fd_sc_hd__xor2_2
X_1062_ _1874_/Q _0999_/X _1337_/A1 _1886_/Q VGND VGND VPWR VPWR _1062_/X sky130_fd_sc_hd__a22o_2
X_1131_ _2001_/Q _1138_/A2 _1138_/B1 _2005_/Q _1082_/Y VGND VGND VPWR VPWR _1131_/X
+ sky130_fd_sc_hd__a221o_2
XFILLER_33_243 VGND VGND VPWR VPWR sky130_fd_sc_hd__fill_2
XFILLER_18_240 VGND VGND VPWR VPWR sky130_fd_sc_hd__decap_3
Xclkbuf_leaf_13_clk clkbuf_leaf_3_clk/A VGND VGND VPWR VPWR clkload8/A sky130_fd_sc_hd__clkbuf_8
X_1964_ _2064_/CLK _1964_/D VGND VGND VPWR VPWR _1964_/Q sky130_fd_sc_hd__dfxtp_2
X_1895_ clkload6/A _1895_/D VGND VGND VPWR VPWR _1895_/Q sky130_fd_sc_hd__dfxtp_2
XFILLER_0_309 VGND VGND VPWR VPWR sky130_fd_sc_hd__decap_3
X_1329_ _1862_/Q _1330_/B _1328_/Y _1403_/C1 VGND VGND VPWR VPWR _1862_/D sky130_fd_sc_hd__o211a_2
XFILLER_24_287 VGND VGND VPWR VPWR sky130_fd_sc_hd__decap_3
XFILLER_3_169 VGND VGND VPWR VPWR sky130_fd_sc_hd__decap_3
XFILLER_15_232 VGND VGND VPWR VPWR sky130_fd_sc_hd__decap_3
XTAP_TAPCELL_ROW_17_205 VGND VPWR sky130_fd_sc_hd__tapvpwrvgnd_1
XFILLER_15_298 VGND VGND VPWR VPWR sky130_fd_sc_hd__decap_3
X_1680_ hold146/X _1676_/X _1679_/Y VGND VGND VPWR VPWR _2009_/D sky130_fd_sc_hd__a21o_2
X_1114_ _1113_/X _1112_/X _1145_/S VGND VGND VPWR VPWR _1114_/X sky130_fd_sc_hd__mux2_1
XTAP_TAPCELL_ROW_0_106 VGND VPWR sky130_fd_sc_hd__tapvpwrvgnd_1
Xclkbuf_leaf_2_clk clkbuf_leaf_2_clk/A VGND VGND VPWR VPWR _2064_/CLK sky130_fd_sc_hd__clkbuf_8
X_2094_ clkload9/A input3/X VGND VGND VPWR VPWR _2094_/Q sky130_fd_sc_hd__dfxtp_2
X_1045_ _1265_/A _1265_/B _1265_/C VGND VGND VPWR VPWR _1236_/B sky130_fd_sc_hd__a21o_2
X_1947_ _2035_/CLK _1947_/D VGND VGND VPWR VPWR _1947_/Q sky130_fd_sc_hd__dfxtp_2
XTAP_TAPCELL_ROW_31_285 VGND VPWR sky130_fd_sc_hd__tapvpwrvgnd_1
X_1878_ clkload5/A _1878_/D VGND VGND VPWR VPWR _1878_/Q sky130_fd_sc_hd__dfxtp_2
XFILLER_9_70 VGND VGND VPWR VPWR sky130_fd_sc_hd__decap_3
XFILLER_9_92 VGND VGND VPWR VPWR sky130_fd_sc_hd__fill_1
XTAP_TAPCELL_ROW_39_330 VGND VPWR sky130_fd_sc_hd__tapvpwrvgnd_1
XFILLER_28_24 VGND VGND VPWR VPWR sky130_fd_sc_hd__decap_3
XFILLER_8_206 VGND VGND VPWR VPWR sky130_fd_sc_hd__decap_3
XFILLER_12_202 VGND VGND VPWR VPWR sky130_fd_sc_hd__decap_3
XFILLER_12_235 VGND VGND VPWR VPWR sky130_fd_sc_hd__decap_3
XFILLER_12_246 VGND VGND VPWR VPWR sky130_fd_sc_hd__decap_3
X_1732_ _2034_/Q _1735_/C _1736_/B VGND VGND VPWR VPWR _1732_/Y sky130_fd_sc_hd__o21ai_2
X_1663_ _2000_/Q _1661_/X _1662_/Y VGND VGND VPWR VPWR _2000_/D sky130_fd_sc_hd__a21o_2
X_1801_ _1807_/A1 _2065_/Q _1805_/B1 _1800_/X VGND VGND VPWR VPWR _2066_/D sky130_fd_sc_hd__o211a_2
X_1594_ hold140/X _2049_/Q _1597_/S VGND VGND VPWR VPWR _1960_/D sky130_fd_sc_hd__mux2_1
XPHY_EDGE_ROW_7_Right_7 VGND VGND VPWR VPWR sky130_fd_sc_hd__decap_3
XTAP_TAPCELL_ROW_36_311 VGND VPWR sky130_fd_sc_hd__tapvpwrvgnd_1
XFILLER_26_305 VGND VGND VPWR VPWR sky130_fd_sc_hd__decap_3
X_2077_ _2077_/CLK _2077_/D VGND VGND VPWR VPWR _2077_/Q sky130_fd_sc_hd__dfxtp_2
X_1028_ _1028_/A _1028_/B _1890_/Q VGND VGND VPWR VPWR _1029_/D sky130_fd_sc_hd__and3_2
XFILLER_39_45 VGND VGND VPWR VPWR sky130_fd_sc_hd__fill_2
XFILLER_29_121 VGND VGND VPWR VPWR sky130_fd_sc_hd__fill_2
XFILLER_44_146 VGND VGND VPWR VPWR sky130_fd_sc_hd__decap_3
XFILLER_44_102 VGND VGND VPWR VPWR sky130_fd_sc_hd__decap_3
XFILLER_52_190 VGND VGND VPWR VPWR sky130_fd_sc_hd__decap_3
XTAP_TAPCELL_ROW_50_391 VGND VPWR sky130_fd_sc_hd__tapvpwrvgnd_1
XTAP_TAPCELL_ROW_42_347 VGND VPWR sky130_fd_sc_hd__tapvpwrvgnd_1
XFILLER_4_286 VGND VGND VPWR VPWR sky130_fd_sc_hd__decap_3
XFILLER_4_275 VGND VGND VPWR VPWR sky130_fd_sc_hd__fill_1
XFILLER_4_220 VGND VGND VPWR VPWR sky130_fd_sc_hd__fill_2
X_2000_ _2001_/CLK _2000_/D VGND VGND VPWR VPWR _2000_/Q sky130_fd_sc_hd__dfxtp_2
XFILLER_35_113 VGND VGND VPWR VPWR sky130_fd_sc_hd__decap_3
XFILLER_35_179 VGND VGND VPWR VPWR sky130_fd_sc_hd__decap_3
X_1646_ _1676_/A _1653_/B VGND VGND VPWR VPWR _1646_/X sky130_fd_sc_hd__or2_2
X_1715_ _2025_/Q _1714_/B _1714_/Y _1809_/B1 VGND VGND VPWR VPWR _2025_/D sky130_fd_sc_hd__o211a_2
X_1577_ _1950_/Q _1579_/B VGND VGND VPWR VPWR _1577_/X sky130_fd_sc_hd__and2_2
XFILLER_49_249 VGND VGND VPWR VPWR sky130_fd_sc_hd__fill_1
XFILLER_2_29 VGND VGND VPWR VPWR sky130_fd_sc_hd__decap_3
XFILLER_9_323 VGND VGND VPWR VPWR sky130_fd_sc_hd__fill_1
XFILLER_17_157 VGND VGND VPWR VPWR sky130_fd_sc_hd__decap_3
XFILLER_31_90 VGND VGND VPWR VPWR sky130_fd_sc_hd__decap_3
X_1500_ _1500_/A _1500_/B VGND VGND VPWR VPWR _1516_/B sky130_fd_sc_hd__and2_2
X_1431_ _1905_/Q _1431_/B VGND VGND VPWR VPWR _1432_/B sky130_fd_sc_hd__nand2_2
X_1362_ _1877_/Q _1365_/B _1361_/Y _1389_/C1 VGND VGND VPWR VPWR _1877_/D sky130_fd_sc_hd__o211a_2
X_1293_ _2012_/Q _1296_/A _1187_/Y VGND VGND VPWR VPWR _1294_/D sky130_fd_sc_hd__a21oi_2
X_1629_ _1796_/B _1629_/B _1675_/B VGND VGND VPWR VPWR _1638_/B sky130_fd_sc_hd__or3_2
XFILLER_46_208 VGND VGND VPWR VPWR sky130_fd_sc_hd__decap_3
XFILLER_52_12 VGND VGND VPWR VPWR sky130_fd_sc_hd__decap_3
XFILLER_10_322 VGND VGND VPWR VPWR sky130_fd_sc_hd__fill_2
XTAP_TAPCELL_ROW_9_164 VGND VPWR sky130_fd_sc_hd__tapvpwrvgnd_1
X_0931_ _2115_/Q VGND VGND VPWR VPWR _0931_/Y sky130_fd_sc_hd__inv_2
X_1980_ _2065_/CLK _1980_/D VGND VGND VPWR VPWR _1980_/Q sky130_fd_sc_hd__dfxtp_2
XFILLER_9_131 VGND VGND VPWR VPWR sky130_fd_sc_hd__decap_3
XFILLER_9_197 VGND VGND VPWR VPWR sky130_fd_sc_hd__decap_3
X_1414_ _1292_/X _1294_/X _0929_/Y _0994_/Y VGND VGND VPWR VPWR _1418_/A sky130_fd_sc_hd__o211a_2
X_1345_ _1869_/Q _1352_/B _1344_/Y _1395_/C1 VGND VGND VPWR VPWR _1869_/D sky130_fd_sc_hd__o211a_2
X_1276_ _1257_/B _1274_/Y _1275_/Y _1228_/B _0993_/A VGND VGND VPWR VPWR _1276_/X
+ sky130_fd_sc_hd__o221a_2
XTAP_TAPCELL_ROW_6_145 VGND VPWR sky130_fd_sc_hd__tapvpwrvgnd_1
XFILLER_42_211 VGND VGND VPWR VPWR sky130_fd_sc_hd__fill_2
Xdig_top_104 VGND VGND VPWR VPWR dig_top_104/HI uio_out[2] sky130_fd_sc_hd__conb_1
XFILLER_10_130 VGND VGND VPWR VPWR sky130_fd_sc_hd__fill_2
X_1130_ _1997_/Q _1137_/A2 _1441_/B _2009_/Q VGND VGND VPWR VPWR _1130_/X sky130_fd_sc_hd__a22o_2
XFILLER_19_6 VGND VGND VPWR VPWR sky130_fd_sc_hd__fill_1
XFILLER_33_200 VGND VGND VPWR VPWR sky130_fd_sc_hd__decap_3
X_1061_ _1222_/B _1228_/A _1201_/A _1208_/A _1222_/A VGND VGND VPWR VPWR _1061_/X
+ sky130_fd_sc_hd__o2111a_2
X_1963_ _1963_/CLK _1963_/D VGND VGND VPWR VPWR _1963_/Q sky130_fd_sc_hd__dfxtp_2
X_1894_ _1899_/CLK _1894_/D VGND VGND VPWR VPWR _1894_/Q sky130_fd_sc_hd__dfxtp_2
X_1328_ _1330_/B _1404_/A VGND VGND VPWR VPWR _1328_/Y sky130_fd_sc_hd__nand2_2
XFILLER_24_200 VGND VGND VPWR VPWR sky130_fd_sc_hd__decap_3
X_1259_ _1039_/X _1228_/B _1258_/Y _1266_/B1 VGND VGND VPWR VPWR _1259_/X sky130_fd_sc_hd__o31a_2
XPHY_EDGE_ROW_49_Left_102 VGND VGND VPWR VPWR sky130_fd_sc_hd__decap_3
XTAP_TAPCELL_ROW_25_250 VGND VPWR sky130_fd_sc_hd__tapvpwrvgnd_1
XFILLER_15_200 VGND VGND VPWR VPWR sky130_fd_sc_hd__decap_3
XFILLER_15_244 VGND VGND VPWR VPWR sky130_fd_sc_hd__decap_3
XTAP_TAPCELL_ROW_17_206 VGND VPWR sky130_fd_sc_hd__tapvpwrvgnd_1
XTAP_TAPCELL_ROW_48_375 VGND VPWR sky130_fd_sc_hd__tapvpwrvgnd_1
X_1113_ _1950_/Q _1954_/Q _1958_/Q _1962_/Q _1113_/S0 _1141_/S1 VGND VGND VPWR VPWR
+ _1113_/X sky130_fd_sc_hd__mux4_2
XTAP_TAPCELL_ROW_0_107 VGND VPWR sky130_fd_sc_hd__tapvpwrvgnd_1
X_1044_ _1265_/A _1265_/B _1265_/C VGND VGND VPWR VPWR _1044_/Y sky130_fd_sc_hd__a21oi_2
X_2093_ clkload2/A _2093_/D VGND VGND VPWR VPWR _2093_/Q sky130_fd_sc_hd__dfxtp_2
XFILLER_17_3 VGND VGND VPWR VPWR sky130_fd_sc_hd__fill_2
XFILLER_0_95 VGND VGND VPWR VPWR sky130_fd_sc_hd__fill_1
XFILLER_21_225 VGND VGND VPWR VPWR sky130_fd_sc_hd__fill_1
XFILLER_21_269 VGND VGND VPWR VPWR sky130_fd_sc_hd__decap_3
X_1946_ _2035_/CLK _1946_/D VGND VGND VPWR VPWR _1946_/Q sky130_fd_sc_hd__dfxtp_2
XTAP_TAPCELL_ROW_31_286 VGND VPWR sky130_fd_sc_hd__tapvpwrvgnd_1
X_1877_ clkload6/A _1877_/D VGND VGND VPWR VPWR _1877_/Q sky130_fd_sc_hd__dfxtp_2
XFILLER_0_107 VGND VGND VPWR VPWR sky130_fd_sc_hd__decap_3
XFILLER_8_218 VGND VGND VPWR VPWR sky130_fd_sc_hd__fill_1
XFILLER_12_214 VGND VGND VPWR VPWR sky130_fd_sc_hd__fill_2
X_1800_ _1806_/A _2066_/Q VGND VGND VPWR VPWR _1800_/X sky130_fd_sc_hd__or2_2
X_1731_ _1735_/C _1736_/B _1731_/C VGND VGND VPWR VPWR _2033_/D sky130_fd_sc_hd__and3b_2
X_1662_ _1677_/A _1668_/B VGND VGND VPWR VPWR _1662_/Y sky130_fd_sc_hd__nor2_2
XFILLER_7_262 VGND VGND VPWR VPWR sky130_fd_sc_hd__decap_3
XFILLER_7_295 VGND VGND VPWR VPWR sky130_fd_sc_hd__fill_1
X_1593_ _1645_/A _1604_/B VGND VGND VPWR VPWR _1597_/S sky130_fd_sc_hd__nor2_2
XFILLER_38_144 VGND VGND VPWR VPWR sky130_fd_sc_hd__decap_3
XTAP_TAPCELL_ROW_36_312 VGND VPWR sky130_fd_sc_hd__tapvpwrvgnd_1
X_1027_ _1028_/B _1878_/Q _1028_/A VGND VGND VPWR VPWR _1029_/C sky130_fd_sc_hd__and3b_2
X_2076_ clkload2/A _2076_/D VGND VGND VPWR VPWR _2076_/Q sky130_fd_sc_hd__dfxtp_2
X_1929_ clkload3/A _1929_/D VGND VGND VPWR VPWR _1929_/Q sky130_fd_sc_hd__dfxtp_2
XFILLER_14_27 VGND VGND VPWR VPWR sky130_fd_sc_hd__fill_1
XFILLER_14_38 VGND VGND VPWR VPWR sky130_fd_sc_hd__fill_1
XFILLER_39_57 VGND VGND VPWR VPWR sky130_fd_sc_hd__fill_1
XFILLER_29_111 VGND VGND VPWR VPWR sky130_fd_sc_hd__fill_1
XFILLER_44_125 VGND VGND VPWR VPWR sky130_fd_sc_hd__decap_3
XFILLER_35_169 VGND VGND VPWR VPWR sky130_fd_sc_hd__fill_2
X_1645_ _1645_/A _1675_/B VGND VGND VPWR VPWR _1653_/B sky130_fd_sc_hd__or2_2
X_1576_ _1626_/A _1497_/A _1505_/X _1575_/X VGND VGND VPWR VPWR _1949_/D sky130_fd_sc_hd__a31o_2
X_1714_ _1506_/A _1714_/B VGND VGND VPWR VPWR _1714_/Y sky130_fd_sc_hd__nand2b_2
XFILLER_22_320 VGND VGND VPWR VPWR sky130_fd_sc_hd__decap_3
X_2059_ clkload1/A _2059_/D VGND VGND VPWR VPWR _2059_/Q sky130_fd_sc_hd__dfxtp_2
XFILLER_14_309 VGND VGND VPWR VPWR sky130_fd_sc_hd__decap_3
XFILLER_17_169 VGND VGND VPWR VPWR sky130_fd_sc_hd__decap_3
XFILLER_25_180 VGND VGND VPWR VPWR sky130_fd_sc_hd__decap_3
XFILLER_9_302 VGND VGND VPWR VPWR sky130_fd_sc_hd__decap_3
X_1430_ _1905_/Q _1431_/B VGND VGND VPWR VPWR _1432_/A sky130_fd_sc_hd__or2_2
X_1361_ _1386_/A _1365_/B VGND VGND VPWR VPWR _1361_/Y sky130_fd_sc_hd__nand2_2
XFILLER_0_290 VGND VGND VPWR VPWR sky130_fd_sc_hd__decap_3
X_1292_ _1255_/X _1286_/Y _1287_/Y _1291_/X VGND VGND VPWR VPWR _1292_/X sky130_fd_sc_hd__o211a_2
XFILLER_16_191 VGND VGND VPWR VPWR sky130_fd_sc_hd__decap_3
XFILLER_31_194 VGND VGND VPWR VPWR sky130_fd_sc_hd__decap_3
XFILLER_31_172 VGND VGND VPWR VPWR sky130_fd_sc_hd__fill_2
X_1559_ hold161/X _1624_/B _1560_/S VGND VGND VPWR VPWR _1942_/D sky130_fd_sc_hd__mux2_1
X_1628_ _1628_/A _1631_/B VGND VGND VPWR VPWR _1675_/B sky130_fd_sc_hd__or2_2
XTAP_TAPCELL_ROW_9_165 VGND VPWR sky130_fd_sc_hd__tapvpwrvgnd_1
X_0930_ _2109_/Q VGND VGND VPWR VPWR _0930_/Y sky130_fd_sc_hd__inv_2
XFILLER_9_110 VGND VGND VPWR VPWR sky130_fd_sc_hd__fill_2
XFILLER_47_3 VGND VGND VPWR VPWR sky130_fd_sc_hd__decap_3
X_1413_ hold198/X _1850_/A _1412_/Y VGND VGND VPWR VPWR _1901_/D sky130_fd_sc_hd__a21oi_2
X_1344_ _1394_/A _1352_/B VGND VGND VPWR VPWR _1344_/Y sky130_fd_sc_hd__nand2_2
X_1275_ _1275_/A _1275_/B VGND VGND VPWR VPWR _1275_/Y sky130_fd_sc_hd__xnor2_2
XFILLER_51_223 VGND VGND VPWR VPWR sky130_fd_sc_hd__fill_1
XFILLER_3_319 VGND VGND VPWR VPWR sky130_fd_sc_hd__decap_3
XFILLER_0_9 VGND VGND VPWR VPWR sky130_fd_sc_hd__decap_3
XTAP_TAPCELL_ROW_6_146 VGND VPWR sky130_fd_sc_hd__tapvpwrvgnd_1
XFILLER_47_57 VGND VGND VPWR VPWR sky130_fd_sc_hd__fill_1
XPHY_EDGE_ROW_29_Right_29 VGND VGND VPWR VPWR sky130_fd_sc_hd__decap_3
Xdig_top_105 VGND VGND VPWR VPWR dig_top_105/HI uio_out[3] sky130_fd_sc_hd__conb_1
XFILLER_42_278 VGND VGND VPWR VPWR sky130_fd_sc_hd__fill_2
XPHY_EDGE_ROW_38_Right_38 VGND VGND VPWR VPWR sky130_fd_sc_hd__decap_3
XFILLER_12_82 VGND VGND VPWR VPWR sky130_fd_sc_hd__fill_2
XFILLER_12_93 VGND VGND VPWR VPWR sky130_fd_sc_hd__fill_2
XPHY_EDGE_ROW_47_Right_47 VGND VGND VPWR VPWR sky130_fd_sc_hd__decap_3
X_1060_ _1210_/B _1208_/A VGND VGND VPWR VPWR _1201_/B sky130_fd_sc_hd__and2b_2
XFILLER_18_231 VGND VGND VPWR VPWR sky130_fd_sc_hd__decap_3
XTAP_TAPCELL_ROW_28_270 VGND VPWR sky130_fd_sc_hd__tapvpwrvgnd_1
X_1962_ _1963_/CLK _1962_/D VGND VGND VPWR VPWR _1962_/Q sky130_fd_sc_hd__dfxtp_2
X_1893_ clkload7/A _1893_/D VGND VGND VPWR VPWR _1893_/Q sky130_fd_sc_hd__dfxtp_2
X_1327_ _1327_/A _1327_/B _1327_/C VGND VGND VPWR VPWR _1404_/A sky130_fd_sc_hd__or3_2
X_1258_ _1258_/A _1258_/B VGND VGND VPWR VPWR _1258_/Y sky130_fd_sc_hd__nor2_2
X_1189_ _1709_/A _1189_/B _1189_/C VGND VGND VPWR VPWR _1189_/X sky130_fd_sc_hd__or3_2
XFILLER_17_27 VGND VGND VPWR VPWR sky130_fd_sc_hd__decap_3
XFILLER_33_37 VGND VGND VPWR VPWR sky130_fd_sc_hd__fill_2
XTAP_TAPCELL_ROW_25_251 VGND VPWR sky130_fd_sc_hd__tapvpwrvgnd_1
XFILLER_15_256 VGND VGND VPWR VPWR sky130_fd_sc_hd__decap_3
XFILLER_15_289 VGND VGND VPWR VPWR sky130_fd_sc_hd__decap_3
XTAP_TAPCELL_ROW_17_207 VGND VPWR sky130_fd_sc_hd__tapvpwrvgnd_1
XFILLER_38_304 VGND VGND VPWR VPWR sky130_fd_sc_hd__decap_3
XFILLER_31_6 VGND VGND VPWR VPWR sky130_fd_sc_hd__decap_3
XTAP_TAPCELL_ROW_48_376 VGND VPWR sky130_fd_sc_hd__tapvpwrvgnd_1
X_1112_ _1966_/Q _1970_/Q _1974_/Q _1978_/Q _1113_/S0 _1141_/S1 VGND VGND VPWR VPWR
+ _1112_/X sky130_fd_sc_hd__mux4_2
X_1043_ _1236_/A _1043_/B VGND VGND VPWR VPWR _1265_/C sky130_fd_sc_hd__nand2_2
XFILLER_0_85 VGND VGND VPWR VPWR sky130_fd_sc_hd__decap_3
XTAP_TAPCELL_ROW_0_108 VGND VPWR sky130_fd_sc_hd__tapvpwrvgnd_1
X_2092_ fanout93/X _2092_/D _1756_/A VGND VGND VPWR VPWR _2092_/Q sky130_fd_sc_hd__dfrtp_2
X_1945_ clkload3/A _1945_/D VGND VGND VPWR VPWR _1945_/Q sky130_fd_sc_hd__dfxtp_2
XFILLER_9_61 VGND VGND VPWR VPWR sky130_fd_sc_hd__decap_3
XFILLER_21_259 VGND VGND VPWR VPWR sky130_fd_sc_hd__fill_1
X_1876_ clkload5/A _1876_/D VGND VGND VPWR VPWR _1876_/Q sky130_fd_sc_hd__dfxtp_2
XFILLER_0_119 VGND VGND VPWR VPWR sky130_fd_sc_hd__decap_3
XFILLER_44_47 VGND VGND VPWR VPWR sky130_fd_sc_hd__fill_1
XFILLER_12_226 VGND VGND VPWR VPWR sky130_fd_sc_hd__decap_3
XFILLER_20_281 VGND VGND VPWR VPWR sky130_fd_sc_hd__fill_1
XTAP_TAPCELL_ROW_22_232 VGND VPWR sky130_fd_sc_hd__tapvpwrvgnd_1
XFILLER_47_167 VGND VGND VPWR VPWR sky130_fd_sc_hd__fill_1
XFILLER_18_81 VGND VGND VPWR VPWR sky130_fd_sc_hd__decap_3
X_1730_ _2031_/Q _2032_/Q _2033_/Q VGND VGND VPWR VPWR _1735_/C sky130_fd_sc_hd__and3_2
X_1661_ _1676_/A _1668_/B VGND VGND VPWR VPWR _1661_/X sky130_fd_sc_hd__or2_2
X_1592_ hold183/X _1626_/B _1592_/S VGND VGND VPWR VPWR _1959_/D sky130_fd_sc_hd__mux2_1
XFILLER_7_274 VGND VGND VPWR VPWR sky130_fd_sc_hd__decap_3
XFILLER_11_281 VGND VGND VPWR VPWR sky130_fd_sc_hd__fill_1
XFILLER_11_292 VGND VGND VPWR VPWR sky130_fd_sc_hd__fill_2
XTAP_TAPCELL_ROW_36_313 VGND VPWR sky130_fd_sc_hd__tapvpwrvgnd_1
X_1026_ _1028_/A _1028_/B _1854_/Q VGND VGND VPWR VPWR _1029_/B sky130_fd_sc_hd__nor3b_2
XFILLER_26_318 VGND VGND VPWR VPWR sky130_fd_sc_hd__decap_3
X_2075_ clkload2/A _2075_/D VGND VGND VPWR VPWR _2075_/Q sky130_fd_sc_hd__dfxtp_2
X_1928_ clkload3/A _1928_/D VGND VGND VPWR VPWR _1928_/Q sky130_fd_sc_hd__dfxtp_2
XFILLER_30_27 VGND VGND VPWR VPWR sky130_fd_sc_hd__fill_1
X_1859_ clkload7/A _1859_/D VGND VGND VPWR VPWR _1859_/Q sky130_fd_sc_hd__dfxtp_2
XFILLER_40_321 VGND VGND VPWR VPWR sky130_fd_sc_hd__decap_3
XFILLER_4_266 VGND VGND VPWR VPWR sky130_fd_sc_hd__decap_3
XFILLER_4_244 VGND VGND VPWR VPWR sky130_fd_sc_hd__fill_2
XFILLER_4_233 VGND VGND VPWR VPWR sky130_fd_sc_hd__decap_3
XFILLER_29_80 VGND VGND VPWR VPWR sky130_fd_sc_hd__decap_3
X_1713_ _2024_/Q _1714_/B _1712_/Y _1809_/B1 VGND VGND VPWR VPWR _2024_/D sky130_fd_sc_hd__o211a_2
X_1644_ hold134/X _1626_/B _1644_/S VGND VGND VPWR VPWR _1991_/D sky130_fd_sc_hd__mux2_1
X_1575_ _1949_/Q _1579_/B VGND VGND VPWR VPWR _1575_/X sky130_fd_sc_hd__and2_2
XFILLER_6_95 VGND VGND VPWR VPWR sky130_fd_sc_hd__decap_3
XFILLER_41_107 VGND VGND VPWR VPWR sky130_fd_sc_hd__decap_3
XFILLER_34_170 VGND VGND VPWR VPWR sky130_fd_sc_hd__fill_1
X_1009_ _1861_/Q _1137_/A2 _1337_/B2 _1897_/Q _1008_/X VGND VGND VPWR VPWR _1201_/A
+ sky130_fd_sc_hd__a221o_2
XFILLER_25_16 VGND VGND VPWR VPWR sky130_fd_sc_hd__fill_2
X_2058_ _2058_/CLK _2058_/D VGND VGND VPWR VPWR _2058_/Q sky130_fd_sc_hd__dfxtp_2
XFILLER_9_6 VGND VGND VPWR VPWR sky130_fd_sc_hd__fill_1
XFILLER_13_310 VGND VGND VPWR VPWR sky130_fd_sc_hd__fill_1
XFILLER_13_321 VGND VGND VPWR VPWR sky130_fd_sc_hd__decap_3
X_1360_ _1876_/Q _1365_/B _1359_/Y _1389_/C1 VGND VGND VPWR VPWR _1876_/D sky130_fd_sc_hd__o211a_2
XFILLER_48_251 VGND VGND VPWR VPWR sky130_fd_sc_hd__fill_1
X_1291_ _1289_/X _1290_/Y _1255_/A _1255_/B _1255_/C VGND VGND VPWR VPWR _1291_/X
+ sky130_fd_sc_hd__a2111o_2
X_1558_ _1941_/Q _1622_/B _1560_/S VGND VGND VPWR VPWR _1941_/D sky130_fd_sc_hd__mux2_1
X_1489_ _1794_/B _1792_/B _1790_/B VGND VGND VPWR VPWR _1489_/Y sky130_fd_sc_hd__nor3b_2
X_1627_ hold160/X _1619_/X _1626_/X VGND VGND VPWR VPWR _1983_/D sky130_fd_sc_hd__a21o_2
XTAP_TAPCELL_ROW_52_400 VGND VPWR sky130_fd_sc_hd__tapvpwrvgnd_1
XFILLER_7_3 VGND VGND VPWR VPWR sky130_fd_sc_hd__decap_3
XFILLER_26_81 VGND VGND VPWR VPWR sky130_fd_sc_hd__decap_3
XFILLER_13_151 VGND VGND VPWR VPWR sky130_fd_sc_hd__fill_1
XFILLER_42_80 VGND VGND VPWR VPWR sky130_fd_sc_hd__decap_3
XFILLER_9_188 VGND VGND VPWR VPWR sky130_fd_sc_hd__decap_3
X_1412_ _1901_/Q _1850_/A _1831_/C VGND VGND VPWR VPWR _1412_/Y sky130_fd_sc_hd__o21ai_2
X_1343_ _1868_/Q _1342_/B _1342_/Y _1395_/C1 VGND VGND VPWR VPWR _1868_/D sky130_fd_sc_hd__o211a_2
XFILLER_3_74 VGND VGND VPWR VPWR sky130_fd_sc_hd__decap_3
XFILLER_51_213 VGND VGND VPWR VPWR sky130_fd_sc_hd__fill_1
XFILLER_36_287 VGND VGND VPWR VPWR sky130_fd_sc_hd__decap_3
X_1274_ _1275_/B _1274_/B VGND VGND VPWR VPWR _1274_/Y sky130_fd_sc_hd__xnor2_2
XFILLER_51_279 VGND VGND VPWR VPWR sky130_fd_sc_hd__fill_1
Xclkbuf_leaf_16_clk clkbuf_2_2__f_clk/X VGND VGND VPWR VPWR _1899_/CLK sky130_fd_sc_hd__clkbuf_8
XTAP_TAPCELL_ROW_14_190 VGND VPWR sky130_fd_sc_hd__tapvpwrvgnd_1
X_0989_ _1764_/A _0984_/X _0988_/X VGND VGND VPWR VPWR _2135_/A sky130_fd_sc_hd__o21a_2
XTAP_TAPCELL_ROW_6_147 VGND VPWR sky130_fd_sc_hd__tapvpwrvgnd_1
Xdig_top_106 VGND VGND VPWR VPWR dig_top_106/HI uio_out[4] sky130_fd_sc_hd__conb_1
XFILLER_27_287 VGND VGND VPWR VPWR sky130_fd_sc_hd__decap_3
XFILLER_27_221 VGND VGND VPWR VPWR sky130_fd_sc_hd__decap_3
XFILLER_6_136 VGND VGND VPWR VPWR sky130_fd_sc_hd__decap_3
XFILLER_12_61 VGND VGND VPWR VPWR sky130_fd_sc_hd__fill_1
XPHY_EDGE_ROW_25_Left_78 VGND VGND VPWR VPWR sky130_fd_sc_hd__decap_3
XFILLER_18_243 VGND VGND VPWR VPWR sky130_fd_sc_hd__fill_2
X_1961_ clkload0/A _1961_/D VGND VGND VPWR VPWR _1961_/Q sky130_fd_sc_hd__dfxtp_2
X_1892_ clkload6/A _1892_/D VGND VGND VPWR VPWR _1892_/Q sky130_fd_sc_hd__dfxtp_2
XFILLER_5_180 VGND VGND VPWR VPWR sky130_fd_sc_hd__fill_1
Xclkbuf_leaf_5_clk clkbuf_leaf_9_clk/A VGND VGND VPWR VPWR clkload3/A sky130_fd_sc_hd__clkbuf_8
X_1326_ _1861_/Q _1325_/A _1325_/Y _1403_/C1 VGND VGND VPWR VPWR _1861_/D sky130_fd_sc_hd__o211a_2
XTAP_TAPCELL_ROW_3_128 VGND VPWR sky130_fd_sc_hd__tapvpwrvgnd_1
XFILLER_24_246 VGND VGND VPWR VPWR sky130_fd_sc_hd__fill_1
X_1257_ _1257_/A _1257_/B _1257_/C VGND VGND VPWR VPWR _1257_/X sky130_fd_sc_hd__or3_2
X_1188_ _1189_/B _1189_/C _1709_/A VGND VGND VPWR VPWR _1188_/Y sky130_fd_sc_hd__o21ai_2
XTAP_TAPCELL_ROW_17_208 VGND VPWR sky130_fd_sc_hd__tapvpwrvgnd_1
XTAP_TAPCELL_ROW_25_252 VGND VPWR sky130_fd_sc_hd__tapvpwrvgnd_1
XFILLER_15_235 VGND VGND VPWR VPWR sky130_fd_sc_hd__decap_3
XFILLER_15_268 VGND VGND VPWR VPWR sky130_fd_sc_hd__decap_3
XFILLER_15_279 VGND VGND VPWR VPWR sky130_fd_sc_hd__fill_1
XFILLER_23_60 VGND VGND VPWR VPWR sky130_fd_sc_hd__fill_1
XFILLER_2_194 VGND VGND VPWR VPWR sky130_fd_sc_hd__fill_2
XFILLER_2_161 VGND VGND VPWR VPWR sky130_fd_sc_hd__fill_1
XTAP_TAPCELL_ROW_48_377 VGND VPWR sky130_fd_sc_hd__tapvpwrvgnd_1
X_1111_ _1110_/X _1109_/X _1145_/S VGND VGND VPWR VPWR _1111_/X sky130_fd_sc_hd__mux2_1
X_1042_ _2027_/Q _1104_/A VGND VGND VPWR VPWR _1043_/B sky130_fd_sc_hd__or2_2
XFILLER_0_42 VGND VGND VPWR VPWR sky130_fd_sc_hd__fill_1
XTAP_TAPCELL_ROW_0_109 VGND VPWR sky130_fd_sc_hd__tapvpwrvgnd_1
X_2091_ fanout93/X _2091_/D osc_en VGND VGND VPWR VPWR _2091_/Q sky130_fd_sc_hd__dfrtp_2
X_1944_ _2036_/CLK _1944_/D VGND VGND VPWR VPWR _1944_/Q sky130_fd_sc_hd__dfxtp_2
X_1875_ _2114_/CLK _1875_/D VGND VGND VPWR VPWR _1875_/Q sky130_fd_sc_hd__dfxtp_2
XFILLER_9_73 VGND VGND VPWR VPWR sky130_fd_sc_hd__decap_3
XFILLER_28_27 VGND VGND VPWR VPWR sky130_fd_sc_hd__fill_1
X_1309_ _1309_/A _1324_/B VGND VGND VPWR VPWR _1392_/A sky130_fd_sc_hd__nand2_2
XFILLER_12_205 VGND VGND VPWR VPWR sky130_fd_sc_hd__decap_3
XFILLER_12_249 VGND VGND VPWR VPWR sky130_fd_sc_hd__decap_3
XTAP_TAPCELL_ROW_22_233 VGND VPWR sky130_fd_sc_hd__tapvpwrvgnd_1
XFILLER_11_271 VGND VGND VPWR VPWR sky130_fd_sc_hd__decap_3
X_1660_ _1660_/A _1675_/B VGND VGND VPWR VPWR _1668_/B sky130_fd_sc_hd__or2_2
X_1591_ hold147/X _1624_/B _1592_/S VGND VGND VPWR VPWR _1958_/D sky130_fd_sc_hd__mux2_1
XFILLER_7_242 VGND VGND VPWR VPWR sky130_fd_sc_hd__fill_1
XFILLER_38_102 VGND VGND VPWR VPWR sky130_fd_sc_hd__fill_2
XTAP_TAPCELL_ROW_36_314 VGND VPWR sky130_fd_sc_hd__tapvpwrvgnd_1
Xload_slew70 _1141_/S0 VGND VGND VPWR VPWR _1113_/S0 sky130_fd_sc_hd__clkbuf_4
X_1025_ _1028_/A _1028_/B _1866_/Q VGND VGND VPWR VPWR _1029_/A sky130_fd_sc_hd__and3b_2
XPHY_EDGE_ROW_28_Left_81 VGND VGND VPWR VPWR sky130_fd_sc_hd__decap_3
X_2074_ _2077_/CLK _2074_/D VGND VGND VPWR VPWR _2074_/Q sky130_fd_sc_hd__dfxtp_2
X_1927_ _1963_/CLK _1927_/D VGND VGND VPWR VPWR _1927_/Q sky130_fd_sc_hd__dfxtp_2
X_1858_ _1897_/CLK _1858_/D VGND VGND VPWR VPWR _1858_/Q sky130_fd_sc_hd__dfxtp_2
XPHY_EDGE_ROW_12_Left_65 VGND VGND VPWR VPWR sky130_fd_sc_hd__decap_3
X_1789_ _1809_/A1 _2059_/Q _1789_/B1 _1788_/X VGND VGND VPWR VPWR _2060_/D sky130_fd_sc_hd__o211a_2
XFILLER_44_149 VGND VGND VPWR VPWR sky130_fd_sc_hd__fill_2
XFILLER_37_190 VGND VGND VPWR VPWR sky130_fd_sc_hd__fill_2
XFILLER_52_193 VGND VGND VPWR VPWR sky130_fd_sc_hd__decap_3
XFILLER_4_289 VGND VGND VPWR VPWR sky130_fd_sc_hd__fill_2
XFILLER_35_116 VGND VGND VPWR VPWR sky130_fd_sc_hd__fill_2
XFILLER_31_322 VGND VGND VPWR VPWR sky130_fd_sc_hd__fill_2
X_1643_ hold190/X _1624_/B _1644_/S VGND VGND VPWR VPWR _1990_/D sky130_fd_sc_hd__mux2_1
X_1712_ _1521_/A _1714_/B VGND VGND VPWR VPWR _1712_/Y sky130_fd_sc_hd__nand2b_2
X_1574_ hold165/X _1579_/B _1573_/X VGND VGND VPWR VPWR _1948_/D sky130_fd_sc_hd__a21bo_2
XFILLER_6_85 VGND VGND VPWR VPWR sky130_fd_sc_hd__fill_2
X_2057_ clkload1/A _2057_/D VGND VGND VPWR VPWR _2057_/Q sky130_fd_sc_hd__dfxtp_2
XFILLER_19_190 VGND VGND VPWR VPWR sky130_fd_sc_hd__fill_2
X_1008_ _1873_/Q _1138_/A2 _1138_/B1 _1885_/Q VGND VGND VPWR VPWR _1008_/X sky130_fd_sc_hd__a22o_2
XFILLER_31_60 VGND VGND VPWR VPWR sky130_fd_sc_hd__decap_3
XFILLER_31_93 VGND VGND VPWR VPWR sky130_fd_sc_hd__decap_3
XFILLER_0_281 VGND VGND VPWR VPWR sky130_fd_sc_hd__decap_3
X_1290_ _1290_/A _1290_/B VGND VGND VPWR VPWR _1290_/Y sky130_fd_sc_hd__nand2_2
X_1626_ _1626_/A _1626_/B _1626_/C VGND VGND VPWR VPWR _1626_/X sky130_fd_sc_hd__and3_2
X_1557_ hold154/X _1620_/B _1560_/S VGND VGND VPWR VPWR _1940_/D sky130_fd_sc_hd__mux2_1
X_1488_ _1772_/B _1919_/Q _1488_/S VGND VGND VPWR VPWR _1919_/D sky130_fd_sc_hd__mux2_1
XTAP_TAPCELL_ROW_52_401 VGND VPWR sky130_fd_sc_hd__tapvpwrvgnd_1
XFILLER_52_15 VGND VGND VPWR VPWR sky130_fd_sc_hd__decap_3
X_2109_ _2115_/CLK _2109_/D VGND VGND VPWR VPWR _2109_/Q sky130_fd_sc_hd__dfxtp_2
XFILLER_36_38 VGND VGND VPWR VPWR sky130_fd_sc_hd__decap_3
XFILLER_52_26 VGND VGND VPWR VPWR sky130_fd_sc_hd__fill_2
XFILLER_10_303 VGND VGND VPWR VPWR sky130_fd_sc_hd__decap_3
XFILLER_22_141 VGND VGND VPWR VPWR sky130_fd_sc_hd__decap_3
XFILLER_45_222 VGND VGND VPWR VPWR sky130_fd_sc_hd__fill_2
XFILLER_9_134 VGND VGND VPWR VPWR sky130_fd_sc_hd__fill_1
XFILLER_13_130 VGND VGND VPWR VPWR sky130_fd_sc_hd__fill_2
X_1411_ _1850_/A _1850_/B VGND VGND VPWR VPWR _1900_/D sky130_fd_sc_hd__nor2_2
X_1342_ _1392_/A _1342_/B VGND VGND VPWR VPWR _1342_/Y sky130_fd_sc_hd__nand2_2
XFILLER_3_53 VGND VGND VPWR VPWR sky130_fd_sc_hd__decap_3
X_1273_ _2014_/Q _1302_/A _1271_/X _1272_/Y VGND VGND VPWR VPWR _1294_/B sky130_fd_sc_hd__a211oi_2
XFILLER_36_266 VGND VGND VPWR VPWR sky130_fd_sc_hd__decap_3
XFILLER_36_244 VGND VGND VPWR VPWR sky130_fd_sc_hd__decap_3
X_0988_ _0985_/Y _0986_/X _0987_/X _2047_/Q _2048_/Q VGND VGND VPWR VPWR _0988_/X
+ sky130_fd_sc_hd__a221o_2
XTAP_TAPCELL_ROW_14_191 VGND VPWR sky130_fd_sc_hd__tapvpwrvgnd_1
X_1609_ _1790_/B _1614_/B _1792_/B VGND VGND VPWR VPWR _1613_/S sky130_fd_sc_hd__nor3b_2
XTAP_TAPCELL_ROW_6_148 VGND VPWR sky130_fd_sc_hd__tapvpwrvgnd_1
Xdig_top_107 VGND VGND VPWR VPWR dig_top_107/HI uio_out[5] sky130_fd_sc_hd__conb_1
XFILLER_12_73 VGND VGND VPWR VPWR sky130_fd_sc_hd__decap_3
XPHY_EDGE_ROW_0_Left_53 VGND VGND VPWR VPWR sky130_fd_sc_hd__decap_3
XFILLER_33_225 VGND VGND VPWR VPWR sky130_fd_sc_hd__fill_1
XFILLER_33_203 VGND VGND VPWR VPWR sky130_fd_sc_hd__decap_3
XFILLER_18_277 VGND VGND VPWR VPWR sky130_fd_sc_hd__decap_3
X_1960_ _2065_/CLK _1960_/D VGND VGND VPWR VPWR _1960_/Q sky130_fd_sc_hd__dfxtp_2
X_1891_ clkload6/A _1891_/D VGND VGND VPWR VPWR _1891_/Q sky130_fd_sc_hd__dfxtp_2
XFILLER_52_3 VGND VGND VPWR VPWR sky130_fd_sc_hd__fill_2
XTAP_TAPCELL_ROW_11_172 VGND VPWR sky130_fd_sc_hd__tapvpwrvgnd_1
X_1325_ _1325_/A _1402_/A VGND VGND VPWR VPWR _1325_/Y sky130_fd_sc_hd__nand2_2
XTAP_TAPCELL_ROW_3_129 VGND VPWR sky130_fd_sc_hd__tapvpwrvgnd_1
X_1256_ _1258_/B _1256_/B VGND VGND VPWR VPWR _1257_/C sky130_fd_sc_hd__and2_2
XFILLER_24_225 VGND VGND VPWR VPWR sky130_fd_sc_hd__decap_3
X_1187_ _1189_/B _1189_/C VGND VGND VPWR VPWR _1187_/Y sky130_fd_sc_hd__nor2_2
XFILLER_32_280 VGND VGND VPWR VPWR sky130_fd_sc_hd__decap_3
XPHY_EDGE_ROW_42_Left_95 VGND VGND VPWR VPWR sky130_fd_sc_hd__decap_3
XTAP_TAPCELL_ROW_17_209 VGND VPWR sky130_fd_sc_hd__tapvpwrvgnd_1
XFILLER_30_217 VGND VGND VPWR VPWR sky130_fd_sc_hd__decap_3
XTAP_TAPCELL_ROW_25_253 VGND VPWR sky130_fd_sc_hd__tapvpwrvgnd_1
XFILLER_48_80 VGND VGND VPWR VPWR sky130_fd_sc_hd__decap_3
XFILLER_38_317 VGND VGND VPWR VPWR sky130_fd_sc_hd__decap_3
X_1110_ _1918_/Q _1922_/Q _1926_/Q _1930_/Q _1113_/S0 _1144_/S1 VGND VGND VPWR VPWR
+ _1110_/X sky130_fd_sc_hd__mux4_2
X_2090_ fanout93/X _2090_/D osc_en VGND VGND VPWR VPWR _2090_/Q sky130_fd_sc_hd__dfrtp_2
XTAP_TAPCELL_ROW_48_378 VGND VPWR sky130_fd_sc_hd__tapvpwrvgnd_1
XFILLER_0_54 VGND VGND VPWR VPWR sky130_fd_sc_hd__fill_2
X_1041_ _2027_/Q _1104_/A VGND VGND VPWR VPWR _1041_/X sky130_fd_sc_hd__and2b_2
X_1943_ _2035_/CLK _1943_/D VGND VGND VPWR VPWR _1943_/Q sky130_fd_sc_hd__dfxtp_2
X_1874_ _1897_/CLK _1874_/D VGND VGND VPWR VPWR _1874_/Q sky130_fd_sc_hd__dfxtp_2
XFILLER_14_291 VGND VGND VPWR VPWR sky130_fd_sc_hd__fill_2
X_1239_ _1267_/A _1163_/C _1163_/A VGND VGND VPWR VPWR _1240_/B sky130_fd_sc_hd__a21o_2
X_1308_ _1855_/Q _1310_/A _1307_/Y _1723_/C1 VGND VGND VPWR VPWR _1855_/D sky130_fd_sc_hd__o211a_2
XTAP_TAPCELL_ROW_22_234 VGND VPWR sky130_fd_sc_hd__tapvpwrvgnd_1
XFILLER_20_272 VGND VGND VPWR VPWR sky130_fd_sc_hd__fill_1
XTAP_TAPCELL_ROW_45_359 VGND VPWR sky130_fd_sc_hd__tapvpwrvgnd_1
XFILLER_7_221 VGND VGND VPWR VPWR sky130_fd_sc_hd__decap_3
XFILLER_7_265 VGND VGND VPWR VPWR sky130_fd_sc_hd__decap_3
XFILLER_11_261 VGND VGND VPWR VPWR sky130_fd_sc_hd__fill_1
X_1590_ hold141/X _1622_/B _1592_/S VGND VGND VPWR VPWR _1957_/D sky130_fd_sc_hd__mux2_1
XFILLER_38_147 VGND VGND VPWR VPWR sky130_fd_sc_hd__decap_3
XFILLER_26_309 VGND VGND VPWR VPWR sky130_fd_sc_hd__decap_3
X_1024_ _2027_/Q _1104_/A VGND VGND VPWR VPWR _1236_/A sky130_fd_sc_hd__nand2_2
XFILLER_15_3 VGND VGND VPWR VPWR sky130_fd_sc_hd__decap_3
X_2073_ _2077_/CLK _2073_/D VGND VGND VPWR VPWR _2073_/Q sky130_fd_sc_hd__dfxtp_2
Xload_slew71 _1083_/S0 VGND VGND VPWR VPWR _1141_/S0 sky130_fd_sc_hd__clkbuf_4
X_1926_ _1963_/CLK _1926_/D VGND VGND VPWR VPWR _1926_/Q sky130_fd_sc_hd__dfxtp_2
XFILLER_30_29 VGND VGND VPWR VPWR sky130_fd_sc_hd__decap_3
X_1788_ _1808_/A _2060_/Q VGND VGND VPWR VPWR _1788_/X sky130_fd_sc_hd__or2_2
X_1857_ clkload7/A _1857_/D VGND VGND VPWR VPWR _1857_/Q sky130_fd_sc_hd__dfxtp_2
XFILLER_29_169 VGND VGND VPWR VPWR sky130_fd_sc_hd__fill_2
XFILLER_25_320 VGND VGND VPWR VPWR sky130_fd_sc_hd__decap_3
XFILLER_45_81 VGND VGND VPWR VPWR sky130_fd_sc_hd__decap_3
XTAP_TAPCELL_ROW_41_340 VGND VPWR sky130_fd_sc_hd__tapvpwrvgnd_1
X_1642_ hold173/X _1622_/B _1644_/S VGND VGND VPWR VPWR _1989_/D sky130_fd_sc_hd__mux2_1
XFILLER_6_42 VGND VGND VPWR VPWR sky130_fd_sc_hd__fill_1
XFILLER_6_64 VGND VGND VPWR VPWR sky130_fd_sc_hd__fill_1
X_1711_ _2070_/Q _2069_/Q _1711_/C VGND VGND VPWR VPWR _1714_/B sky130_fd_sc_hd__and3_2
X_1573_ _1640_/C _1619_/B _1573_/C _1620_/B VGND VGND VPWR VPWR _1573_/X sky130_fd_sc_hd__or4b_2
X_1007_ _1899_/Q _1337_/B2 _1138_/B1 _1887_/Q _1005_/X VGND VGND VPWR VPWR _1178_/A
+ sky130_fd_sc_hd__a221o_2
XFILLER_26_128 VGND VGND VPWR VPWR sky130_fd_sc_hd__decap_3
XFILLER_26_117 VGND VGND VPWR VPWR sky130_fd_sc_hd__decap_3
X_2056_ _2058_/CLK _2056_/D VGND VGND VPWR VPWR _2056_/Q sky130_fd_sc_hd__dfxtp_2
X_1909_ _2114_/CLK _1909_/D VGND VGND VPWR VPWR _1909_/Q sky130_fd_sc_hd__dfxtp_2
XFILLER_22_323 VGND VGND VPWR VPWR sky130_fd_sc_hd__fill_1
XFILLER_25_183 VGND VGND VPWR VPWR sky130_fd_sc_hd__decap_3
XFILLER_25_161 VGND VGND VPWR VPWR sky130_fd_sc_hd__fill_1
XFILLER_9_305 VGND VGND VPWR VPWR sky130_fd_sc_hd__decap_3
XFILLER_17_139 VGND VGND VPWR VPWR sky130_fd_sc_hd__decap_3
XFILLER_40_197 VGND VGND VPWR VPWR sky130_fd_sc_hd__decap_3
XFILLER_31_72 VGND VGND VPWR VPWR sky130_fd_sc_hd__fill_2
XFILLER_0_293 VGND VGND VPWR VPWR sky130_fd_sc_hd__decap_3
XFILLER_31_197 VGND VGND VPWR VPWR sky130_fd_sc_hd__decap_3
XFILLER_16_194 VGND VGND VPWR VPWR sky130_fd_sc_hd__fill_2
X_1556_ _1598_/B _1670_/A VGND VGND VPWR VPWR _1560_/S sky130_fd_sc_hd__nor2_2
X_1625_ hold182/X _1619_/X _1624_/X VGND VGND VPWR VPWR _1982_/D sky130_fd_sc_hd__a21o_2
X_1487_ _1770_/B hold186/X _1488_/S VGND VGND VPWR VPWR _1918_/D sky130_fd_sc_hd__mux2_1
XFILLER_36_17 VGND VGND VPWR VPWR sky130_fd_sc_hd__fill_2
XTAP_TAPCELL_ROW_52_402 VGND VPWR sky130_fd_sc_hd__tapvpwrvgnd_1
X_2108_ _2114_/CLK _2108_/D VGND VGND VPWR VPWR _2108_/Q sky130_fd_sc_hd__dfxtp_2
X_2039_ _2040_/CLK _2039_/D VGND VGND VPWR VPWR _2039_/Q sky130_fd_sc_hd__dfxtp_2
XFILLER_6_319 VGND VGND VPWR VPWR sky130_fd_sc_hd__decap_3
XFILLER_22_197 VGND VGND VPWR VPWR sky130_fd_sc_hd__decap_3
XFILLER_9_113 VGND VGND VPWR VPWR sky130_fd_sc_hd__decap_3
XFILLER_9_146 VGND VGND VPWR VPWR sky130_fd_sc_hd__fill_2
XFILLER_47_6 VGND VGND VPWR VPWR sky130_fd_sc_hd__fill_1
X_1410_ _1900_/Q _1424_/B _1831_/C VGND VGND VPWR VPWR _1850_/B sky130_fd_sc_hd__o21ai_2
XFILLER_9_179 VGND VGND VPWR VPWR sky130_fd_sc_hd__decap_3
X_1341_ _1867_/Q _1342_/B _1340_/Y _1723_/C1 VGND VGND VPWR VPWR _1867_/D sky130_fd_sc_hd__o211a_2
XFILLER_3_87 VGND VGND VPWR VPWR sky130_fd_sc_hd__fill_2
X_1272_ _2014_/Q _1302_/A _1306_/A _2015_/Q VGND VGND VPWR VPWR _1272_/Y sky130_fd_sc_hd__o22ai_2
XFILLER_36_278 VGND VGND VPWR VPWR sky130_fd_sc_hd__decap_3
X_0987_ _2082_/Q _2084_/Q _2046_/Q VGND VGND VPWR VPWR _0987_/X sky130_fd_sc_hd__mux2_1
XTAP_TAPCELL_ROW_14_192 VGND VPWR sky130_fd_sc_hd__tapvpwrvgnd_1
X_1539_ _1598_/B _1655_/A VGND VGND VPWR VPWR _1543_/S sky130_fd_sc_hd__nor2_2
XTAP_TAPCELL_ROW_6_149 VGND VPWR sky130_fd_sc_hd__tapvpwrvgnd_1
X_1608_ _1971_/Q _1772_/B _1608_/S VGND VGND VPWR VPWR _1971_/D sky130_fd_sc_hd__mux2_1
XFILLER_27_267 VGND VGND VPWR VPWR sky130_fd_sc_hd__decap_3
Xdig_top_108 VGND VGND VPWR VPWR dig_top_108/HI uio_out[6] sky130_fd_sc_hd__conb_1
XFILLER_2_322 VGND VGND VPWR VPWR sky130_fd_sc_hd__fill_2
Xhold190 _1990_/Q VGND VGND VPWR VPWR hold190/X sky130_fd_sc_hd__dlygate4sd3_1
XFILLER_37_60 VGND VGND VPWR VPWR sky130_fd_sc_hd__decap_3
XPHY_EDGE_ROW_16_Right_16 VGND VGND VPWR VPWR sky130_fd_sc_hd__decap_3
XFILLER_18_234 VGND VGND VPWR VPWR sky130_fd_sc_hd__decap_3
XFILLER_41_281 VGND VGND VPWR VPWR sky130_fd_sc_hd__fill_1
X_1890_ clkload5/A _1890_/D VGND VGND VPWR VPWR _1890_/Q sky130_fd_sc_hd__dfxtp_2
XPHY_EDGE_ROW_25_Right_25 VGND VGND VPWR VPWR sky130_fd_sc_hd__decap_3
XTAP_TAPCELL_ROW_11_173 VGND VPWR sky130_fd_sc_hd__tapvpwrvgnd_1
XPHY_EDGE_ROW_34_Right_34 VGND VGND VPWR VPWR sky130_fd_sc_hd__decap_3
X_1255_ _1255_/A _1255_/B _1255_/C _1255_/D VGND VGND VPWR VPWR _1255_/X sky130_fd_sc_hd__or4_2
X_1186_ _1098_/X _1180_/A _1180_/B _1180_/C _1266_/B1 VGND VGND VPWR VPWR _1189_/C
+ sky130_fd_sc_hd__a311oi_2
X_1324_ _1324_/A _1324_/B VGND VGND VPWR VPWR _1402_/A sky130_fd_sc_hd__nand2_2
XTAP_TAPCELL_ROW_34_298 VGND VPWR sky130_fd_sc_hd__tapvpwrvgnd_1
XPHY_EDGE_ROW_43_Right_43 VGND VGND VPWR VPWR sky130_fd_sc_hd__decap_3
XPHY_EDGE_ROW_52_Right_52 VGND VGND VPWR VPWR sky130_fd_sc_hd__decap_3
XFILLER_15_259 VGND VGND VPWR VPWR sky130_fd_sc_hd__fill_2
XFILLER_23_95 VGND VGND VPWR VPWR sky130_fd_sc_hd__fill_1
XFILLER_31_9 VGND VGND VPWR VPWR sky130_fd_sc_hd__fill_1
XFILLER_2_152 VGND VGND VPWR VPWR sky130_fd_sc_hd__decap_3
XFILLER_38_307 VGND VGND VPWR VPWR sky130_fd_sc_hd__fill_1
X_1040_ _1258_/A _1258_/B VGND VGND VPWR VPWR _1265_/B sky130_fd_sc_hd__nand2_2
XTAP_TAPCELL_ROW_48_379 VGND VPWR sky130_fd_sc_hd__tapvpwrvgnd_1
X_1942_ _2035_/CLK _1942_/D VGND VGND VPWR VPWR _1942_/Q sky130_fd_sc_hd__dfxtp_2
XFILLER_14_281 VGND VGND VPWR VPWR sky130_fd_sc_hd__fill_1
X_1873_ _1897_/CLK _1873_/D VGND VGND VPWR VPWR _1873_/Q sky130_fd_sc_hd__dfxtp_2
XFILLER_9_64 VGND VGND VPWR VPWR sky130_fd_sc_hd__decap_3
XFILLER_28_29 VGND VGND VPWR VPWR sky130_fd_sc_hd__decap_3
X_1238_ _1264_/B _1235_/Y _1237_/Y _1228_/B _1266_/B1 VGND VGND VPWR VPWR _1238_/X
+ sky130_fd_sc_hd__o221a_2
X_1169_ _1208_/A _1172_/B VGND VGND VPWR VPWR _1170_/B sky130_fd_sc_hd__nor2_2
X_1307_ _1310_/A _1390_/A VGND VGND VPWR VPWR _1307_/Y sky130_fd_sc_hd__nand2_2
XFILLER_12_229 VGND VGND VPWR VPWR sky130_fd_sc_hd__decap_3
XFILLER_20_251 VGND VGND VPWR VPWR sky130_fd_sc_hd__fill_1
XTAP_TAPCELL_ROW_22_235 VGND VPWR sky130_fd_sc_hd__tapvpwrvgnd_1
XFILLER_34_83 VGND VGND VPWR VPWR sky130_fd_sc_hd__fill_1
XFILLER_7_200 VGND VGND VPWR VPWR sky130_fd_sc_hd__decap_3
XFILLER_7_233 VGND VGND VPWR VPWR sky130_fd_sc_hd__decap_3
XFILLER_7_277 VGND VGND VPWR VPWR sky130_fd_sc_hd__decap_3
XFILLER_34_321 VGND VGND VPWR VPWR sky130_fd_sc_hd__decap_3
X_2072_ _2077_/CLK _2072_/D VGND VGND VPWR VPWR _2072_/Q sky130_fd_sc_hd__dfxtp_2
X_1023_ _1855_/Q _1867_/Q _1879_/Q _1891_/Q _1028_/B _1028_/A VGND VGND VPWR VPWR
+ _1104_/A sky130_fd_sc_hd__mux4_2
X_1925_ _1963_/CLK _1925_/D VGND VGND VPWR VPWR _1925_/Q sky130_fd_sc_hd__dfxtp_2
X_1787_ _1809_/A1 _2058_/Q _1789_/B1 _1786_/X VGND VGND VPWR VPWR _2059_/D sky130_fd_sc_hd__o211a_2
X_1856_ clkload6/A _1856_/D VGND VGND VPWR VPWR _1856_/Q sky130_fd_sc_hd__dfxtp_2
XPHY_EDGE_ROW_2_Right_2 VGND VGND VPWR VPWR sky130_fd_sc_hd__decap_3
XFILLER_4_269 VGND VGND VPWR VPWR sky130_fd_sc_hd__decap_3
XFILLER_20_85 VGND VGND VPWR VPWR sky130_fd_sc_hd__fill_2
XFILLER_29_83 VGND VGND VPWR VPWR sky130_fd_sc_hd__decap_3
XFILLER_43_162 VGND VGND VPWR VPWR sky130_fd_sc_hd__decap_3
XTAP_TAPCELL_ROW_41_341 VGND VPWR sky130_fd_sc_hd__tapvpwrvgnd_1
X_1641_ hold181/X _1620_/B _1644_/S VGND VGND VPWR VPWR _1988_/D sky130_fd_sc_hd__mux2_1
X_1572_ _2065_/Q _1640_/C _1619_/B _1628_/A VGND VGND VPWR VPWR _1579_/B sky130_fd_sc_hd__or4_2
XFILLER_6_98 VGND VGND VPWR VPWR sky130_fd_sc_hd__fill_2
X_1710_ _2060_/Q _1709_/B _1709_/Y _1809_/B1 VGND VGND VPWR VPWR _2023_/D sky130_fd_sc_hd__o211a_2
XFILLER_3_291 VGND VGND VPWR VPWR sky130_fd_sc_hd__decap_3
X_1006_ _1899_/Q _1337_/B2 _1138_/B1 _1887_/Q _1005_/X VGND VGND VPWR VPWR _1064_/A
+ sky130_fd_sc_hd__a221oi_2
X_2055_ _2058_/CLK _2055_/D VGND VGND VPWR VPWR _2055_/Q sky130_fd_sc_hd__dfxtp_2
X_1908_ clkload9/A _1908_/D VGND VGND VPWR VPWR _1908_/Q sky130_fd_sc_hd__dfxtp_2
X_1839_ hold174/X _1834_/Y _1839_/S VGND VGND VPWR VPWR _2108_/D sky130_fd_sc_hd__mux2_1
XFILLER_1_228 VGND VGND VPWR VPWR sky130_fd_sc_hd__fill_2
XFILLER_1_206 VGND VGND VPWR VPWR sky130_fd_sc_hd__fill_1
XFILLER_9_317 VGND VGND VPWR VPWR sky130_fd_sc_hd__decap_3
XFILLER_0_261 VGND VGND VPWR VPWR sky130_fd_sc_hd__decap_3
X_1555_ _1676_/A _1790_/B _1792_/B _2063_/Q VGND VGND VPWR VPWR _1670_/A sky130_fd_sc_hd__or4bb_2
X_1624_ _1626_/A _1624_/B _1626_/C VGND VGND VPWR VPWR _1624_/X sky130_fd_sc_hd__and3_2
X_2107_ _2115_/CLK _2107_/D VGND VGND VPWR VPWR _2107_/Q sky130_fd_sc_hd__dfxtp_2
X_1486_ _1506_/A _1917_/Q _1488_/S VGND VGND VPWR VPWR _1917_/D sky130_fd_sc_hd__mux2_1
Xclkbuf_leaf_19_clk clkbuf_2_2__f_clk/X VGND VGND VPWR VPWR _2040_/CLK sky130_fd_sc_hd__clkbuf_8
XTAP_TAPCELL_ROW_52_403 VGND VPWR sky130_fd_sc_hd__tapvpwrvgnd_1
X_2038_ _2040_/CLK _2038_/D VGND VGND VPWR VPWR _2038_/Q sky130_fd_sc_hd__dfxtp_2
XFILLER_7_6 VGND VGND VPWR VPWR sky130_fd_sc_hd__fill_1
XFILLER_42_94 VGND VGND VPWR VPWR sky130_fd_sc_hd__decap_3
XFILLER_42_83 VGND VGND VPWR VPWR sky130_fd_sc_hd__fill_1
XFILLER_9_169 VGND VGND VPWR VPWR sky130_fd_sc_hd__fill_2
XFILLER_13_110 VGND VGND VPWR VPWR sky130_fd_sc_hd__fill_2
X_1340_ _1390_/A _1342_/B VGND VGND VPWR VPWR _1340_/Y sky130_fd_sc_hd__nand2_2
XFILLER_3_77 VGND VGND VPWR VPWR sky130_fd_sc_hd__fill_1
X_1271_ _2015_/Q _1306_/A VGND VGND VPWR VPWR _1271_/X sky130_fd_sc_hd__and2_2
Xclkbuf_leaf_8_clk clkbuf_leaf_9_clk/A VGND VGND VPWR VPWR clkload4/A sky130_fd_sc_hd__clkbuf_8
X_0986_ _2046_/Q _2078_/Q _2047_/Q VGND VGND VPWR VPWR _0986_/X sky130_fd_sc_hd__o21ba_2
XTAP_TAPCELL_ROW_14_193 VGND VPWR sky130_fd_sc_hd__tapvpwrvgnd_1
X_1538_ _1599_/A _1796_/B _1794_/B VGND VGND VPWR VPWR _1655_/A sky130_fd_sc_hd__or3b_2
X_1469_ _1640_/C _1626_/A VGND VGND VPWR VPWR _1500_/A sky130_fd_sc_hd__nand2_2
X_1607_ hold163/X _2051_/Q _1608_/S VGND VGND VPWR VPWR _1970_/D sky130_fd_sc_hd__mux2_1
Xdig_top_109 VGND VGND VPWR VPWR dig_top_109/HI uio_out[7] sky130_fd_sc_hd__conb_1
XFILLER_42_238 VGND VGND VPWR VPWR sky130_fd_sc_hd__fill_2
Xhold180 _1933_/Q VGND VGND VPWR VPWR hold180/X sky130_fd_sc_hd__dlygate4sd3_1
XFILLER_6_139 VGND VGND VPWR VPWR sky130_fd_sc_hd__fill_1
Xhold191 _1927_/Q VGND VGND VPWR VPWR hold191/X sky130_fd_sc_hd__dlygate4sd3_1
XFILLER_37_72 VGND VGND VPWR VPWR sky130_fd_sc_hd__fill_2
XFILLER_18_268 VGND VGND VPWR VPWR sky130_fd_sc_hd__decap_3
XTAP_TAPCELL_ROW_11_174 VGND VPWR sky130_fd_sc_hd__tapvpwrvgnd_1
X_1323_ _1860_/Q _1325_/A _1322_/Y _1403_/C1 VGND VGND VPWR VPWR _1860_/D sky130_fd_sc_hd__o211a_2
X_1254_ _1290_/A _1254_/B _1254_/C _1254_/D VGND VGND VPWR VPWR _1255_/D sky130_fd_sc_hd__or4_2
X_1185_ _1064_/A _1061_/X _1064_/X _1266_/B1 VGND VGND VPWR VPWR _1189_/B sky130_fd_sc_hd__o211a_2
XTAP_TAPCELL_ROW_34_299 VGND VPWR sky130_fd_sc_hd__tapvpwrvgnd_1
X_0969_ a_selb0[0] VGND VGND VPWR VPWR a_sel0[0] sky130_fd_sc_hd__inv_2
XFILLER_15_238 VGND VGND VPWR VPWR sky130_fd_sc_hd__decap_3
XFILLER_23_271 VGND VGND VPWR VPWR sky130_fd_sc_hd__decap_3
XFILLER_2_197 VGND VGND VPWR VPWR sky130_fd_sc_hd__decap_3
XFILLER_2_120 VGND VGND VPWR VPWR sky130_fd_sc_hd__decap_3
XFILLER_0_12 VGND VGND VPWR VPWR sky130_fd_sc_hd__decap_3
X_1941_ clkload3/A _1941_/D VGND VGND VPWR VPWR _1941_/Q sky130_fd_sc_hd__dfxtp_2
X_1872_ clkload9/A _1872_/D VGND VGND VPWR VPWR _1872_/Q sky130_fd_sc_hd__dfxtp_2
XFILLER_9_76 VGND VGND VPWR VPWR sky130_fd_sc_hd__fill_1
XTAP_TAPCELL_ROW_16_200 VGND VPWR sky130_fd_sc_hd__tapvpwrvgnd_1
X_1306_ _1306_/A _1327_/B _1327_/C VGND VGND VPWR VPWR _1390_/A sky130_fd_sc_hd__or3_2
XFILLER_44_29 VGND VGND VPWR VPWR sky130_fd_sc_hd__fill_1
X_1237_ _1245_/B _1237_/B VGND VGND VPWR VPWR _1237_/Y sky130_fd_sc_hd__nand2_2
XFILLER_12_208 VGND VGND VPWR VPWR sky130_fd_sc_hd__decap_3
X_1168_ _1208_/A _1172_/B VGND VGND VPWR VPWR _1190_/B sky130_fd_sc_hd__and2_2
X_1099_ _1100_/A _1172_/B VGND VGND VPWR VPWR _1099_/Y sky130_fd_sc_hd__nand2_2
XTAP_TAPCELL_ROW_30_280 VGND VPWR sky130_fd_sc_hd__tapvpwrvgnd_1
XTAP_TAPCELL_ROW_22_236 VGND VPWR sky130_fd_sc_hd__tapvpwrvgnd_1
XFILLER_34_62 VGND VGND VPWR VPWR sky130_fd_sc_hd__decap_3
XFILLER_50_72 VGND VGND VPWR VPWR sky130_fd_sc_hd__fill_1
XFILLER_7_256 VGND VGND VPWR VPWR sky130_fd_sc_hd__decap_3
XFILLER_11_252 VGND VGND VPWR VPWR sky130_fd_sc_hd__decap_3
XFILLER_11_274 VGND VGND VPWR VPWR sky130_fd_sc_hd__fill_1
Xload_slew73 _1143_/S0 VGND VGND VPWR VPWR _1144_/S0 sky130_fd_sc_hd__buf_4
XFILLER_38_138 VGND VGND VPWR VPWR sky130_fd_sc_hd__fill_2
X_1022_ _2028_/Q _1102_/A VGND VGND VPWR VPWR _1245_/A sky130_fd_sc_hd__nand2_2
X_2071_ clkload2/A _2071_/D VGND VGND VPWR VPWR _2071_/Q sky130_fd_sc_hd__dfxtp_2
X_1924_ clkload3/A _1924_/D VGND VGND VPWR VPWR _1924_/Q sky130_fd_sc_hd__dfxtp_2
X_1855_ clkload6/A _1855_/D VGND VGND VPWR VPWR _1855_/Q sky130_fd_sc_hd__dfxtp_2
XFILLER_39_18 VGND VGND VPWR VPWR sky130_fd_sc_hd__decap_3
X_1786_ _1808_/A _2059_/Q VGND VGND VPWR VPWR _1786_/X sky130_fd_sc_hd__or2_2
XFILLER_40_314 VGND VGND VPWR VPWR sky130_fd_sc_hd__fill_2
XTAP_TAPCELL_ROW_50_386 VGND VPWR sky130_fd_sc_hd__tapvpwrvgnd_1
XFILLER_4_204 VGND VGND VPWR VPWR sky130_fd_sc_hd__decap_3
XFILLER_45_72 VGND VGND VPWR VPWR sky130_fd_sc_hd__fill_1
XFILLER_28_193 VGND VGND VPWR VPWR sky130_fd_sc_hd__decap_3
XFILLER_28_171 VGND VGND VPWR VPWR sky130_fd_sc_hd__decap_3
XFILLER_16_322 VGND VGND VPWR VPWR sky130_fd_sc_hd__fill_2
X_1571_ hold116/X _1563_/X _1570_/Y VGND VGND VPWR VPWR _1947_/D sky130_fd_sc_hd__a21o_2
X_1640_ _1588_/A _1640_/B _1640_/C VGND VGND VPWR VPWR _1644_/S sky130_fd_sc_hd__and3b_2
XFILLER_6_11 VGND VGND VPWR VPWR sky130_fd_sc_hd__fill_2
XPHY_EDGE_ROW_16_Left_69 VGND VGND VPWR VPWR sky130_fd_sc_hd__decap_3
XFILLER_20_3 VGND VGND VPWR VPWR sky130_fd_sc_hd__decap_3
X_1005_ _1863_/Q _1137_/A2 _1138_/A2 _1875_/Q VGND VGND VPWR VPWR _1005_/X sky130_fd_sc_hd__a22o_2
X_2054_ clkload1/A _2054_/D VGND VGND VPWR VPWR _2054_/Q sky130_fd_sc_hd__dfxtp_2
X_1838_ hold170/X _1832_/X _1839_/S VGND VGND VPWR VPWR _2107_/D sky130_fd_sc_hd__mux2_1
X_1907_ clkload9/A _1907_/D VGND VGND VPWR VPWR _1907_/Q sky130_fd_sc_hd__dfxtp_2
X_1769_ _1807_/A1 _2049_/Q _1805_/B1 _1768_/X VGND VGND VPWR VPWR _2050_/D sky130_fd_sc_hd__o211a_2
XFILLER_25_141 VGND VGND VPWR VPWR sky130_fd_sc_hd__decap_3
XFILLER_40_166 VGND VGND VPWR VPWR sky130_fd_sc_hd__decap_3
XFILLER_25_196 VGND VGND VPWR VPWR sky130_fd_sc_hd__decap_3
XFILLER_15_53 VGND VGND VPWR VPWR sky130_fd_sc_hd__decap_3
XFILLER_31_63 VGND VGND VPWR VPWR sky130_fd_sc_hd__decap_3
XFILLER_0_284 VGND VGND VPWR VPWR sky130_fd_sc_hd__decap_3
XFILLER_0_251 VGND VGND VPWR VPWR sky130_fd_sc_hd__fill_1
XFILLER_31_122 VGND VGND VPWR VPWR sky130_fd_sc_hd__decap_3
XFILLER_16_141 VGND VGND VPWR VPWR sky130_fd_sc_hd__decap_3
XFILLER_31_155 VGND VGND VPWR VPWR sky130_fd_sc_hd__decap_3
X_1554_ hold124/X _1546_/X _1553_/Y VGND VGND VPWR VPWR _1939_/D sky130_fd_sc_hd__a21o_2
X_1485_ _1521_/A _1916_/Q _1488_/S VGND VGND VPWR VPWR _1916_/D sky130_fd_sc_hd__mux2_1
X_1623_ hold153/X _1619_/X _1622_/X VGND VGND VPWR VPWR _1981_/D sky130_fd_sc_hd__a21o_2
.ends
